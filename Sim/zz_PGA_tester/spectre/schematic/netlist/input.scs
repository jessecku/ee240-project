// Design: final_project/zz_PGA_tester
simulator lang=spectre
global 0
parameters Lmin=1u WLn=25u WLp=62u vin=30m cap=20n ratio=3
include "/home/ff/ee140/fa19/xfab/XKIT/xt018/cadence/v8_0/spectre/v8_0_2/lp5mos/config.scs" section=default
include "/home/ff/ee140/fa19/xfab/XKIT/xt018/cadence/v8_0/spectre/v8_0_2/lp5mos/param.scs" section=3s
include "/home/ff/ee140/fa19/xfab/XKIT/xt018/cadence/v8_0/spectre/v8_0_2/lp5mos/bip.scs" section=tm
include "/home/ff/ee140/fa19/xfab/XKIT/xt018/cadence/v8_0/spectre/v8_0_2/lp5mos/cap.scs" section=tm
include "/home/ff/ee140/fa19/xfab/XKIT/xt018/cadence/v8_0/spectre/v8_0_2/lp5mos/dio.scs" section=tm
include "/home/ff/ee140/fa19/xfab/XKIT/xt018/cadence/v8_0/spectre/v8_0_2/lp5mos/mos.scs" section=tm
include "/home/ff/ee140/fa19/xfab/XKIT/xt018/cadence/v8_0/spectre/v8_0_2/lp5mos/res.scs" section=tm

// final_project/inverter/schematic
subckt inverter IN OUT VDD VSS
    M0 (OUT IN VSS VSS) ne w=220.0n l=180.0n m=(1)*(1)
    M1 (OUT IN VDD VDD) pe w=220.0n l=180.0n m=(1)*(1)
ends inverter

// final_project/mux2/schematic
subckt mux2 S\<0\> VDD VSS in0 in1 out
    W1 (in0 out net8 VSS) relay vt1=100m vt2=900m ropen=1T rclosed=1.0
    W0 (in1 out S\<0\> VSS) relay vt1=100m vt2=900.0m ropen=1T rclosed=1.0
    I0 (S\<0\> net8 VDD VSS) inverter
ends mux2

// final_project/PGA/schematic
subckt PGA CLK_PGA_1 CLK_PGA_2 G\<2\> G\<1\> G\<0\> VDD VIN VOUT VSS
    C2 (net9 net034) capacitor c=4*cap
    C7 (net9 net032) capacitor c=cap
    C1 (net9 net033) capacitor c=2*cap
    C4 (net9 VOUT) capacitor c=cap
    C0 (net014 net9) capacitor c=cap
    I1 (G\<1\> VDD VSS VSS net040 B\<1\>) mux2
    I2 (G\<2\> VDD VSS VSS net039 B\<2\>) mux2
    I0 (G\<0\> VDD VSS VSS net041 B\<0\>) mux2
    W9 (net034 B\<2\> CLK_PGA_2 VSS) relay ropen=1T rclosed=1.0
    W8 (net034 VIN CLK_PGA_1 VSS) relay ropen=1T rclosed=1.0
    W22 (net032 VIN CLK_PGA_1 VSS) relay ropen=1T rclosed=1.0
    W3 (net033 B\<1\> CLK_PGA_2 VSS) relay ropen=1T rclosed=1.0
    W2 (net033 VIN CLK_PGA_1 VSS) relay ropen=1T rclosed=1.0
    W23 (net032 B\<0\> CLK_PGA_2 VSS) relay ropen=1T rclosed=1.0
    W1 (net014 VSS CLK_PGA_2 VSS) relay ropen=1T rclosed=1.0
    W21 (VOUT net9 CLK_PGA_1 VSS) relay ropen=1T rclosed=1.0
    W0 (net014 VIN CLK_PGA_1 VSS) relay ropen=1T rclosed=1.0
    E1 (VOUT VSS VSS net9) vcvs gain=2000
ends PGA

// final_project/zz_PGA_tester/schematic
I2 (CLK_PGA_1 CLK_PGA_2 net07\<0\> net07\<1\> net07\<2\> net03 net3 net5 0) PGA
V6 (G\<2\> 0) vsource dc=0 type=dc
V5 (G\<1\> 0) vsource dc=1.2 type=dc
V4 (G\<0\> 0) vsource dc=1.2 type=dc
V3 (net3 0) vsource dc=vin type=dc
V0 (net03 0) vsource dc=1.2 type=dc
V2 (CLK_PGA_2 0) vsource type=pulse val0=1.2 val1=0 period=10u delay=2u rise=10n fall=10n width=1u
V1 (CLK_PGA_1 0) vsource type=pulse val0=0 val1=1.2V period=10u delay=2u rise=10n fall=10n width=1u
R0 (net5 0) resistor r=100K
simulatorOptions options reltol=100e-6 temp=27 homotopy=all limit=delta compatible=spice2
tran tran stop=20u errpreset=conservative
save I2:7 I2:8 I2:6 I2:9 I2:2 I2:1 V3:p V3:p
