// Design: final_project/zz_PGA_tester
simulator lang=spectre
global 0
parameters Lmin=1u WLn=25u WLp=62u
include "/home/ff/ee140/fa19/xfab/XKIT/xt018/cadence/v8_0/spectre/v8_0_2/lp5mos/config.scs" section=default
include "/home/ff/ee140/fa19/xfab/XKIT/xt018/cadence/v8_0/spectre/v8_0_2/lp5mos/param.scs" section=3s
include "/home/ff/ee140/fa19/xfab/XKIT/xt018/cadence/v8_0/spectre/v8_0_2/lp5mos/bip.scs" section=tm
include "/home/ff/ee140/fa19/xfab/XKIT/xt018/cadence/v8_0/spectre/v8_0_2/lp5mos/cap.scs" section=tm
include "/home/ff/ee140/fa19/xfab/XKIT/xt018/cadence/v8_0/spectre/v8_0_2/lp5mos/dio.scs" section=tm
include "/home/ff/ee140/fa19/xfab/XKIT/xt018/cadence/v8_0/spectre/v8_0_2/lp5mos/mos.scs" section=tm
include "/home/ff/ee140/fa19/xfab/XKIT/xt018/cadence/v8_0/spectre/v8_0_2/lp5mos/res.scs" section=tm

// lab5/pmos_cascode_wrap/schematic
subckt pmos_cascode_wrap INN INP OUT VDD VSS
    M23 (net062 net062 VDD VDD) pel w=0.5*WLp l=Lmin m=(1)*(1)
    M22 (net052 net062 VDD VDD) pel w=1*WLp l=Lmin m=(1)*(1)
    M27 (net063 net014 VDD VDD) pel w=0.5*WLp l=Lmin m=(1)*(1)
    M12 (net039 net014 VDD VDD) pel w=0.5*WLp l=Lmin m=(1)*(1)
    M11 (net014 net014 VDD VDD) pel w=0.5*WLp l=Lmin m=(1)*(1)
    M7 (net11 net014 VDD VDD) pel w=WLp l=Lmin m=(1)*(1)
    M6 (net044 INP net11 net11) pel w=0.5*WLp l=Lmin m=(1)*(1)
    M4 (net20 net20 VDD VDD) pel w=0.5*WLp l=Lmin m=(1)*(1)
    M3 (net19 net19 net20 net20) pel w=0.5*WLp l=Lmin m=(1)*(1)
    M2 (OUT net19 net23 net23) pel w=0.5*WLp l=Lmin m=(1)*(1)
    M1 (net23 net20 VDD VDD) pel w=0.5*WLp l=Lmin m=(1)*(1)
    M5 (net35 INN net11 net11) pel w=0.5*WLp l=Lmin m=(1)*(1)
    M24 (net052 net052 VSS VSS) nel w=0.2*WLn l=Lmin m=(1)*(1)
    M26 (net063 net063 VSS VSS) nel w=0.5*WLn l=Lmin m=(1)*(1)
    M25 (net062 net063 VSS VSS) nel w=0.5*WLn l=Lmin m=(1)*(1)
    M14 (net039 net039 VSS VSS) nel w=0.5*WLn l=Lmin m=(1)*(1)
    M13 (net014 net039 net051 net051) nel w=2*WLn l=Lmin m=(1)*(1)
    M10 (net35 net063 VSS VSS) nel w=1*WLn l=Lmin m=(1)*(1)
    M9 (OUT net052 net35 net35) nel w=0.5*WLn l=Lmin m=(1)*(1)
    M8 (net044 net063 VSS VSS) nel w=1*WLn l=Lmin m=(1)*(1)
    M0 (net19 net052 net044 net044) nel w=0.5*WLn l=Lmin m=(1)*(1)
    R0 (net051 VSS) resistor r=10k
ends pmos_cascode_wrap

// final_project/inverter/schematic
subckt inverter IN OUT VDD VSS
    M0 (OUT IN VSS VSS) ne w=220.0n l=180.0n m=(1)*(1)
    M1 (OUT IN VDD VDD) pe w=220.0n l=180.0n m=(1)*(1)
ends inverter

// final_project/PGA/schematic
subckt PGA CLK VDD VIN VOUT VSS G\<2\> G\<1\> G\<0\>
    R1 (VSS G\<2\>) resistor r=1K
    R3 (VSS G\<0\>) resistor r=1K
    R0 (VSS G\<1\>) resistor r=1K
    C4 (net9 VOUT) capacitor c=40f
    C0 (net014 net9) capacitor c=400f
    I4 (net9 VSS VOUT VDD VSS) pmos_cascode_wrap
    W1 (VIN VSS CLK2 VSS) relay ropen=1T rclosed=1.0
    W21 (VOUT net9 CLK2 VSS) relay ropen=1T rclosed=1.0
    W0 (net014 VIN CLK1 VSS) relay ropen=1T rclosed=1.0
    I5 (CLK2 CLK1 VDD VSS) inverter
    I3 (CLK CLK2 VDD VSS) inverter
ends PGA

// final_project/zz_PGA_tester/schematic
I0 (net4 net08 net3 net5 0 0 0 0) PGA
V3 (net3 0) vsource dc=10.00m type=dc
V0 (net08 0) vsource dc=1.2 type=dc
V1 (net4 0) vsource type=pulse val0=1.8 val1=-1.8 period=1u
R0 (net5 0) resistor r=100K
simulatorOptions options reltol=100e-6 temp=27 homotopy=all limit=delta compatible=spice2
tran tran stop=10u errpreset=conservative
