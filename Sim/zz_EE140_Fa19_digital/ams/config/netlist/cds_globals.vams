// Verilog-AMS cds_globals module for top-level cell:
//    final_project/zz_EE140_Fa19_digital.
// Generated by ADE.
// Cadence Design Systems, Inc.

// This is an autoGenerated file, any changes done to this file may get lost.

`include "disciplines.vams"
`include "userDisciplines.vams"

module cds_globals;

// Global Signals
   electrical \gnd! ;
   ground \gnd! ;

// Design Variables
   dynamicparam real _EXPR_1 = 1.5e-05;
   dynamicparam real VDD = 1.2;
   dynamicparam real TRISE = 10n;
   dynamicparam real TFALL = 10n;
   dynamicparam real FCLK = 1M;
   dynamicparam real VCOMP = VDD;
   dynamicparam real VCLK = VDD;
   dynamicparam real TSTART = 1/FCLK;

endmodule
