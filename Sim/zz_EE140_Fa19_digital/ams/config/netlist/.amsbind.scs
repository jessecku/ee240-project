// -----------------------------------------------------------------------------
// (c) Copyright 2010 Cadence Design Systems, Inc. All rights reserved worldwide.
// -----------------------------------------------------------------------------

// Binding AMSD Control Block for config final_project.zz_EE140_Fa19_digital:config
// Created On: Nov 29 01:12:52 2019
// NOTE      : DO NOT change this system generated file.

amsd {
	config designtop="final_project.zz_EE140_Fa19_digital:schematic"

	config cell="EE140_Fa19_digital" lib="final_project" view="schematic"
	config cell="NA2HDX0_dupe" lib="ee140_gsi" view="schematic"
	config cell="SAR_DFF" lib="ee140_gsi" view="schematic"
	config cell="SAR_FSM" lib="ee140_gsi" view="functional"
	config cell="pe" view="analogtext"
	config cell="capacitor" view="analogtext"
	config cell="DFRRSHDX0_dupe" lib="ee140_gsi" view="schematic"
	config cell="vsource" view="analogtext"
	config cell="clk_nonoverlapping" lib="final_project" view="schematic"
	config cell="invr_dupe" lib="ee140_gsi" view="schematic"
	config cell="ne" view="analogtext"

 }
