// AMS netlist generated by the AMS Unified netlister
// IC subversion:  IC6.1.7-64b.500.23
// IUS version: 15.20-s076
// Copyright(C) 2005-2009, Cadence Design Systems, Inc
// User: ee140-abc Pid: 10792
// Design library name: final_project
// Design cell name: zz_EE140_Fa19_digital
// Design view name: config
// Solver: Spectre

`include "disciplines.vams"
`include "userDisciplines.vams"
// HDL file - ee140_gsi, SAR_FSM, functional.
// Library - ee140_gsi, Cell - invr_dupe, View - schematic
// LAST TIME SAVED: Nov 19 11:06:49 2019
// NETLIST TIME: Nov 29 01:12:50 2019

`worklib ee140_gsi
`view schematic

`timescale 1ns / 1ps
(* cds_ams_schematic *)

module invr_dupe (out, VDD, VSS, in);
output  out;
input  in;
inout  VDD, VSS;
parameter GT_PDW=0 ;
parameter GT_PDL=1.8e-07 ;
parameter sx=4.8e-07 ;
parameter lc=2.7e-07 ;
parameter GT_PUW=0 ;
parameter GT_PUL=1.8e-07 ;
ne #(.w(GT_PDW), .l(GT_PDL), .as(sx*(GT_PDW)), .ad(sx*(GT_PDW)), .ps(2*(sx+(GT_PDW))), .pd(2*(sx+(GT_PDW))), .nrs(lc/(GT_PDW)), .nrd(lc/(GT_PDW)), .m((1)*(1)), .par1((1)*(1)))
(* integer passed_mfactor = "m"; *)
 ne (out, in, VSS, VSS);
pe #(.w(GT_PUW), .l(GT_PUL), .as(sx*(GT_PUW)), .ad(sx*(GT_PUW)), .ps(2*(sx+(GT_PUW))), .pd(2*(sx+(GT_PUW))), .nrs(lc/(GT_PUW)), .nrd(lc/(GT_PUW)), .m((1)*(1)), .par1((1)*(1)))
(* integer passed_mfactor = "m"; *)
 pe (out, in, VDD, VDD);

endmodule
// Library - ee140_gsi, Cell - NA2HDX0_dupe, View - schematic
// LAST TIME SAVED: Nov 22 13:18:46 2019
// NETLIST TIME: Nov 29 01:12:50 2019

`worklib ee140_gsi
`view schematic

`timescale 1ns / 1ps
(* cds_ams_schematic *)

module NA2HDX0_dupe (Q, VDD, VSS, A, B);
output  Q;
input  A, B;
inout  VDD, VSS;
ne #(.w(4.2e-07), .l(1.8e-07), .as(2.016e-13), .ad(2.016e-13), .ps(1.8e-06), .pd(1.8e-06), .nrs(0.642857), .nrd(0.642857), .m((1)*(1)), .par1((1)*(1)))
(* integer passed_mfactor = "m"; *)
 MN1 (Q, A, net44, VSS);
ne #(.w(4.2e-07), .l(1.8e-07), .as(2.016e-13), .ad(2.016e-13), .ps(1.8e-06), .pd(1.8e-06), .nrs(0.642857), .nrd(0.642857), .m((1)*(1)), .par1((1)*(1)))
(* integer passed_mfactor = "m"; *)
 MN2 (net44, B, VSS, VSS);
pe #(.w(7.2e-07), .l(1.8e-07), .as(3.456e-13), .ad(3.456e-13), .ps(2.4e-06), .pd(2.4e-06), .nrs(0.375), .nrd(0.375), .m((1)*(1)), .par1((1)*(1)))
(* integer passed_mfactor = "m"; *)
 MP1 (Q, A, VDD, VDD);
pe #(.w(7.2e-07), .l(1.8e-07), .as(3.456e-13), .ad(3.456e-13), .ps(2.4e-06), .pd(2.4e-06), .nrs(0.375), .nrd(0.375), .m((1)*(1)), .par1((1)*(1)))
(* integer passed_mfactor = "m"; *)
 MP2 (Q, B, VDD, VDD);

endmodule
// Library - ee140_gsi, Cell - DFRRSHDX0_dupe, View - schematic
// LAST TIME SAVED: Nov 19 18:00:26 2019
// NETLIST TIME: Nov 29 01:12:50 2019

`worklib ee140_gsi
`view schematic

`timescale 1ns / 1ps
(* cds_ams_schematic *)

module DFRRSHDX0_dupe (Q, QN, VDD, VSS, C, D, RN, SN);
output  Q, QN;
input  C, D, RN, SN;
inout  VDD, VSS;
wire CIB;
wire SQI;
wire CI;
wire SQIB;
invr_dupe #(.sx(4.8e-07), .GT_PUW(7.2e-07), .GT_PDL(1.8e-07), .lc(2.7e-07), .GT_PUL(1.8e-07), .GT_PDW(4.2e-07)) I0 (.VSS( VSS ), .VDD( VDD ), .in( C ), .out( CIB ));
invr_dupe #(.sx(4.8e-07), .GT_PUW(7.2e-07), .GT_PDL(1.8e-07), .lc(2.7e-07), .GT_PUL(1.8e-07), .GT_PDW(4.2e-07)) I2 (.VSS( VSS ), .VDD( VDD ), .in( SQI ), .out( QN ));
invr_dupe #(.sx(4.8e-07), .GT_PUW(7.2e-07), .GT_PDL(1.8e-07), .lc(2.7e-07), .GT_PUL(1.8e-07), .GT_PDW(4.2e-07)) I1 (.VSS( VSS ), .VDD( VDD ), .in( CIB ), .out( CI ));
invr_dupe #(.sx(4.8e-07), .GT_PUW(7.2e-07), .GT_PDL(1.8e-07), .lc(2.7e-07), .GT_PUL(1.8e-07), .GT_PDW(4.2e-07)) I3 (.VSS( VSS ), .VDD( VDD ), .in( SQIB ), .out( Q ));
ne #(.w(4.2e-07), .l(1.8e-07), .as(2.016e-13), .ad(2.016e-13), .ps(1.8e-06), .pd(1.8e-06), .nrs(0.642857), .nrd(0.642857), .m((1)*(1)), .par1((1)*(1)))
(* integer passed_mfactor = "m"; *)
 MN10 (SQIB, CI, net268, VSS);
ne #(.w(4.2e-07), .l(1.8e-07), .as(2.016e-13), .ad(2.016e-13), .ps(1.8e-06), .pd(1.8e-06), .nrs(0.642857), .nrd(0.642857), .m((1)*(1)), .par1((1)*(1)))
(* integer passed_mfactor = "m"; *)
 MN14 (SQIB, CIB, net266, VSS);
ne #(.w(4.2e-07), .l(1.8e-07), .as(2.016e-13), .ad(2.016e-13), .ps(1.8e-06), .pd(1.8e-06), .nrs(0.642857), .nrd(0.642857), .m((1)*(1)), .par1((1)*(1)))
(* integer passed_mfactor = "m"; *)
 MN2 (MQIB, CIB, net271, VSS);
ne #(.w(4.2e-07), .l(1.8e-07), .as(2.016e-13), .ad(2.016e-13), .ps(1.8e-06), .pd(1.8e-06), .nrs(0.642857), .nrd(0.642857), .m((1)*(1)), .par1((1)*(1)))
(* integer passed_mfactor = "m"; *)
 MN6 (MQIB, CI, net270, VSS);
ne #(.w(4.2e-07), .l(1.8e-07), .as(2.016e-13), .ad(2.016e-13), .ps(1.8e-06), .pd(1.8e-06), .nrs(0.642857), .nrd(0.642857), .m((1)*(1)), .par1((1)*(1)))
(* integer passed_mfactor = "m"; *)
 MN13 (net266, SQI, net265, VSS);
ne #(.w(5.05e-07), .l(1.8e-07), .as(2.424e-13), .ad(2.424e-13), .ps(1.97e-06), .pd(1.97e-06), .nrs(0.534653), .nrd(0.534653), .m((1)*(1)), .par1((1)*(1)))
(* integer passed_mfactor = "m"; *)
 MN7 (MQI, MQIB, net269, VSS);
ne #(.w(8.9e-07), .l(1.8e-07), .as(4.272e-13), .ad(4.272e-13), .ps(2.74e-06), .pd(2.74e-06), .nrs(0.303371), .nrd(0.303371), .m((1)*(1)), .par1((1)*(1)))
(* integer passed_mfactor = "m"; *)
 MN15 (SQI, SQIB, net264, VSS);
ne #(.w(4.2e-07), .l(1.8e-07), .as(2.016e-13), .ad(2.016e-13), .ps(1.8e-06), .pd(1.8e-06), .nrs(0.642857), .nrd(0.642857), .m((1)*(1)), .par1((1)*(1)))
(* integer passed_mfactor = "m"; *)
 MN9 (net268, MQI, net267, VSS);
ne #(.w(4.2e-07), .l(1.8e-07), .as(2.016e-13), .ad(2.016e-13), .ps(1.8e-06), .pd(1.8e-06), .nrs(0.642857), .nrd(0.642857), .m((1)*(1)), .par1((1)*(1)))
(* integer passed_mfactor = "m"; *)
 MN1 (net271, D, net273, VSS);
ne #(.w(4.2e-07), .l(1.8e-07), .as(2.016e-13), .ad(2.016e-13), .ps(1.8e-06), .pd(1.8e-06), .nrs(0.642857), .nrd(0.642857), .m((1)*(1)), .par1((1)*(1)))
(* integer passed_mfactor = "m"; *)
 MN5 (net270, MQI, net272, VSS);
ne #(.w(4.2e-07), .l(1.8e-07), .as(2.016e-13), .ad(2.016e-13), .ps(1.8e-06), .pd(1.8e-06), .nrs(0.642857), .nrd(0.642857), .m((1)*(1)), .par1((1)*(1)))
(* integer passed_mfactor = "m"; *)
 MN11 (net267, RN, VSS, VSS);
ne #(.w(8.9e-07), .l(1.8e-07), .as(4.272e-13), .ad(4.272e-13), .ps(2.74e-06), .pd(2.74e-06), .nrs(0.303371), .nrd(0.303371), .m((1)*(1)), .par1((1)*(1)))
(* integer passed_mfactor = "m"; *)
 MN16 (net264, SN, VSS, VSS);
ne #(.w(4.2e-07), .l(1.8e-07), .as(2.016e-13), .ad(2.016e-13), .ps(1.8e-06), .pd(1.8e-06), .nrs(0.642857), .nrd(0.642857), .m((1)*(1)), .par1((1)*(1)))
(* integer passed_mfactor = "m"; *)
 MN12 (net265, RN, VSS, VSS);
ne #(.w(5.05e-07), .l(1.8e-07), .as(2.424e-13), .ad(2.424e-13), .ps(1.97e-06), .pd(1.97e-06), .nrs(0.534653), .nrd(0.534653), .m((1)*(1)), .par1((1)*(1)))
(* integer passed_mfactor = "m"; *)
 MN8 (net269, SN, VSS, VSS);
ne #(.w(4.2e-07), .l(1.8e-07), .as(2.016e-13), .ad(2.016e-13), .ps(1.8e-06), .pd(1.8e-06), .nrs(0.642857), .nrd(0.642857), .m((1)*(1)), .par1((1)*(1)))
(* integer passed_mfactor = "m"; *)
 MN3 (net273, RN, VSS, VSS);
ne #(.w(4.2e-07), .l(1.8e-07), .as(2.016e-13), .ad(2.016e-13), .ps(1.8e-06), .pd(1.8e-06), .nrs(0.642857), .nrd(0.642857), .m((1)*(1)), .par1((1)*(1)))
(* integer passed_mfactor = "m"; *)
 MN4 (net272, RN, VSS, VSS);
pe #(.w(9.55e-07), .l(1.8e-07), .as(4.584e-13), .ad(4.584e-13), .ps(2.87e-06), .pd(2.87e-06), .nrs(0.282723), .nrd(0.282723), .m((1)*(1)), .par1((1)*(1)))
(* integer passed_mfactor = "m"; *)
 MP3 (MQIB, RN, VDD, VDD);
pe #(.w(9.25e-07), .l(1.8e-07), .as(4.44e-13), .ad(4.44e-13), .ps(2.81e-06), .pd(2.81e-06), .nrs(0.291892), .nrd(0.291892), .m((1)*(1)), .par1((1)*(1)))
(* integer passed_mfactor = "m"; *)
 MP14 (SQI, SN, VDD, VDD);
pe #(.w(5.05e-07), .l(1.8e-07), .as(2.424e-13), .ad(2.424e-13), .ps(1.97e-06), .pd(1.97e-06), .nrs(0.534653), .nrd(0.534653), .m((1)*(1)), .par1((1)*(1)))
(* integer passed_mfactor = "m"; *)
 MP10 (SQIB, RN, VDD, VDD);
pe #(.w(8.5e-07), .l(1.8e-07), .as(4.08e-13), .ad(4.08e-13), .ps(2.66e-06), .pd(2.66e-06), .nrs(0.317647), .nrd(0.317647), .m((1)*(1)), .par1((1)*(1)))
(* integer passed_mfactor = "m"; *)
 MP6 (MQI, MQIB, VDD, VDD);
pe #(.w(7.15e-07), .l(1.8e-07), .as(3.432e-13), .ad(3.432e-13), .ps(2.39e-06), .pd(2.39e-06), .nrs(0.377622), .nrd(0.377622), .m((1)*(1)), .par1((1)*(1)))
(* integer passed_mfactor = "m"; *)
 MP9 (net261, MQI, VDD, VDD);
pe #(.w(8.5e-07), .l(1.8e-07), .as(4.08e-13), .ad(4.08e-13), .ps(2.66e-06), .pd(2.66e-06), .nrs(0.317647), .nrd(0.317647), .m((1)*(1)), .par1((1)*(1)))
(* integer passed_mfactor = "m"; *)
 MP7 (MQI, SN, VDD, VDD);
pe #(.w(9.25e-07), .l(1.8e-07), .as(4.44e-13), .ad(4.44e-13), .ps(2.81e-06), .pd(2.81e-06), .nrs(0.291892), .nrd(0.291892), .m((1)*(1)), .par1((1)*(1)))
(* integer passed_mfactor = "m"; *)
 MP13 (SQI, SQIB, VDD, VDD);
pe #(.w(4.2e-07), .l(1.8e-07), .as(2.016e-13), .ad(2.016e-13), .ps(1.8e-06), .pd(1.8e-06), .nrs(0.642857), .nrd(0.642857), .m((1)*(1)), .par1((1)*(1)))
(* integer passed_mfactor = "m"; *)
 MP12 (net260, SQI, VDD, VDD);
pe #(.w(4.2e-07), .l(1.8e-07), .as(2.016e-13), .ad(2.016e-13), .ps(1.8e-06), .pd(1.8e-06), .nrs(0.642857), .nrd(0.642857), .m((1)*(1)), .par1((1)*(1)))
(* integer passed_mfactor = "m"; *)
 MP5 (net262, MQI, VDD, VDD);
pe #(.w(7.05e-07), .l(1.8e-07), .as(3.384e-13), .ad(3.384e-13), .ps(2.37e-06), .pd(2.37e-06), .nrs(0.382979), .nrd(0.382979), .m((1)*(1)), .par1((1)*(1)))
(* integer passed_mfactor = "m"; *)
 MP2 (net263, D, VDD, VDD);
pe #(.w(4.2e-07), .l(1.8e-07), .as(2.016e-13), .ad(2.016e-13), .ps(1.8e-06), .pd(1.8e-06), .nrs(0.642857), .nrd(0.642857), .m((1)*(1)), .par1((1)*(1)))
(* integer passed_mfactor = "m"; *)
 MP11 (SQIB, CI, net260, VDD);
pe #(.w(4.2e-07), .l(1.8e-07), .as(2.016e-13), .ad(2.016e-13), .ps(1.8e-06), .pd(1.8e-06), .nrs(0.642857), .nrd(0.642857), .m((1)*(1)), .par1((1)*(1)))
(* integer passed_mfactor = "m"; *)
 MP4 (MQIB, CIB, net262, VDD);
pe #(.w(7.15e-07), .l(1.8e-07), .as(3.432e-13), .ad(3.432e-13), .ps(2.39e-06), .pd(2.39e-06), .nrs(0.377622), .nrd(0.377622), .m((1)*(1)), .par1((1)*(1)))
(* integer passed_mfactor = "m"; *)
 MP8 (SQIB, CIB, net261, VDD);
pe #(.w(7.05e-07), .l(1.8e-07), .as(3.384e-13), .ad(3.384e-13), .ps(2.37e-06), .pd(2.37e-06), .nrs(0.382979), .nrd(0.382979), .m((1)*(1)), .par1((1)*(1)))
(* integer passed_mfactor = "m"; *)
 MP1 (MQIB, CI, net263, VDD);

endmodule
// Library - ee140_gsi, Cell - SAR_DFF, View - schematic
// LAST TIME SAVED: Nov 19 18:00:08 2019
// NETLIST TIME: Nov 29 01:12:50 2019

`worklib ee140_gsi
`view schematic

`timescale 1ns / 1ps
(* cds_ams_schematic *)

module SAR_DFF (D, DONE, VDD, VSS, CLK, COMP, RESETB);
output  DONE;
input  CLK, COMP, RESETB;
inout  VDD, VSS;
output [7:0] D;
wire [0:7] X;
wire net010;
wire net019;
wire net014;
wire net067;
wire net018;
wire net025;
wire net022;
wire net029;
wire net026;
wire net033;
wire net030;
wire net065;
wire net034;
wire net043;
wire net038;
wire net048;
wire net2;
wire net053;
wire net09;
DFRRSHDX0_dupe I18 (.VSS( VSS ), .VDD( VDD ), .Q( DONE ), .QN( net019 ), .D( VSS ), .C( VSS ), .SN( net010 ), .RN( RESETB ));
DFRRSHDX0_dupe I17 (.VSS( VSS ), .VDD( VDD ), .Q( D[0] ), .QN( net067 ), .D( COMP ), .C( DONE ), .SN( net014 ), .RN( RESETB ));
DFRRSHDX0_dupe I16 (.VSS( VSS ), .VDD( VDD ), .Q( D[1] ), .QN( net025 ), .D( COMP ), .C( D[0] ), .SN( net018 ), .RN( RESETB ));
DFRRSHDX0_dupe I15 (.VSS( VSS ), .VDD( VDD ), .Q( D[2] ), .QN( net029 ), .D( COMP ), .C( D[1] ), .SN( net022 ), .RN( RESETB ));
DFRRSHDX0_dupe I14 (.VSS( VSS ), .VDD( VDD ), .Q( D[3] ), .QN( net033 ), .D( COMP ), .C( D[2] ), .SN( net026 ), .RN( RESETB ));
DFRRSHDX0_dupe I13 (.VSS( VSS ), .VDD( VDD ), .Q( D[4] ), .QN( net065 ), .D( COMP ), .C( D[3] ), .SN( net030 ), .RN( RESETB ));
DFRRSHDX0_dupe I12 (.VSS( VSS ), .VDD( VDD ), .Q( D[5] ), .QN( net043 ), .D( COMP ), .C( D[4] ), .SN( net034 ), .RN( RESETB ));
DFRRSHDX0_dupe I11 (.VSS( VSS ), .VDD( VDD ), .Q( D[6] ), .QN( net048 ), .D( COMP ), .C( D[5] ), .SN( net038 ), .RN( RESETB ));
DFRRSHDX0_dupe I10 (.VSS( VSS ), .VDD( VDD ), .Q( D[7] ), .QN( net053 ), .D( COMP ), .C( D[6] ), .SN( net2 ), .RN( RESETB ));
DFRRSHDX0_dupe I8 (.VSS( VSS ), .VDD( VDD ), .Q( net09 ), .QN( net010 ), .D( X[0] ), .C( CLK ), .SN( VDD ), .RN( RESETB ));
DFRRSHDX0_dupe I7 (.VSS( VSS ), .VDD( VDD ), .Q( X[0] ), .QN( net014 ), .D( X[1] ), .C( CLK ), .SN( VDD ), .RN( RESETB ));
DFRRSHDX0_dupe I6 (.VSS( VSS ), .VDD( VDD ), .Q( X[1] ), .QN( net018 ), .D( X[2] ), .C( CLK ), .SN( VDD ), .RN( RESETB ));
DFRRSHDX0_dupe I5 (.VSS( VSS ), .VDD( VDD ), .Q( X[2] ), .QN( net022 ), .D( X[3] ), .C( CLK ), .SN( VDD ), .RN( RESETB ));
DFRRSHDX0_dupe I4 (.VSS( VSS ), .VDD( VDD ), .Q( X[3] ), .QN( net026 ), .D( X[4] ), .C( CLK ), .SN( VDD ), .RN( RESETB ));
DFRRSHDX0_dupe I3 (.VSS( VSS ), .VDD( VDD ), .Q( X[4] ), .QN( net030 ), .D( X[5] ), .C( CLK ), .SN( VDD ), .RN( RESETB ));
DFRRSHDX0_dupe I2 (.VSS( VSS ), .VDD( VDD ), .Q( X[5] ), .QN( net034 ), .D( X[6] ), .C( CLK ), .SN( VDD ), .RN( RESETB ));
DFRRSHDX0_dupe I1 (.VSS( VSS ), .VDD( VDD ), .Q( X[6] ), .QN( net038 ), .D( X[7] ), .C( CLK ), .SN( VDD ), .RN( RESETB ));
DFRRSHDX0_dupe I0 (.VSS( VSS ), .VDD( VDD ), .Q( X[7] ), .QN( net2 ), .D( VSS ), .C( CLK ), .SN( RESETB ), .RN( VDD ));

endmodule
// Library - final_project, Cell - clk_nonoverlapping, View - schematic
// LAST TIME SAVED: Nov 29 01:12:38 2019
// NETLIST TIME: Nov 29 01:12:50 2019

`worklib final_project
`view schematic

`timescale 1ns / 1ps
(* cds_ams_schematic *)

module clk_nonoverlapping (PHI1, PHI2, VDD, VSS, CLK_IN);
output  PHI1, PHI2;
input  CLK_IN;
inout  VDD, VSS;
wire net5;
wire net3;
wire net2;
wire net1;
wire net4;
invr_dupe #(.sx(4.8e-07), .GT_PUW(7.2e-07), .GT_PDL(1.8e-07), .lc(2.7e-07), .GT_PUL(1.8e-07), .GT_PDW(4.2e-07)) I6 (.VSS( VSS ), .VDD( VDD ), .in( CLK_IN ), .out( net5 ));
invr_dupe #(.sx(4.8e-07), .GT_PUW(7.2e-07), .GT_PDL(1.8e-07), .lc(2.7e-07), .GT_PUL(1.8e-07), .GT_PDW(4.2e-07)) I5 (.VSS( VSS ), .VDD( VDD ), .in( net3 ), .out( PHI1 ));
invr_dupe #(.sx(4.8e-07), .GT_PUW(7.2e-07), .GT_PDL(1.8e-07), .lc(2.7e-07), .GT_PUL(1.8e-07), .GT_PDW(4.2e-07)) I4 (.VSS( VSS ), .VDD( VDD ), .in( net2 ), .out( PHI2 ));
invr_dupe #(.sx(4.8e-07), .GT_PUW(7.2e-07), .GT_PDL(1.8e-07), .lc(2.7e-07), .GT_PUL(1.8e-07), .GT_PDW(4.2e-07)) I3 (.VSS( VSS ), .VDD( VDD ), .in( net1 ), .out( net2 ));
invr_dupe #(.sx(4.8e-07), .GT_PUW(7.2e-07), .GT_PDL(1.8e-07), .lc(2.7e-07), .GT_PUL(1.8e-07), .GT_PDW(4.2e-07)) I2 (.VSS( VSS ), .VDD( VDD ), .in( net4 ), .out( net3 ));
NA2HDX0_dupe I7 (.VSS( VSS ), .VDD( VDD ), .B( net5 ), .Q( net1 ), .A( PHI1 ));
NA2HDX0_dupe I0 (.VSS( VSS ), .VDD( VDD ), .B( PHI2 ), .Q( net4 ), .A( CLK_IN ));
capacitor #(.c(1e-13)) C5 (PHI2, VSS);
capacitor #(.c(1e-13)) C4 (PHI1, VSS);
capacitor #(.c(1e-13)) C3 (net3, VSS);
capacitor #(.c(1e-13)) C2 (net4, VSS);
capacitor #(.c(1e-13)) C1 (net2, VSS);
capacitor #(.c(1e-13)) C0 (net1, VSS);

endmodule
// Library - final_project, Cell - EE140_Fa19_digital, View - schematic
// LAST TIME SAVED: Nov 29 01:08:31 2019
// NETLIST TIME: Nov 29 01:12:50 2019

`worklib final_project
`view schematic

`timescale 1ns / 1ps
(* cds_ams_schematic *)

module EE140_Fa19_digital (CLK_ADC, CLK_PGA1, CLK_PGA2, DAC, DONE, VDD, VSS, CLK, COMP, ENABLE);
output  CLK_ADC, CLK_PGA1, CLK_PGA2, DONE;
input  CLK, COMP, ENABLE;
inout  VDD, VSS;
output [7:0] DAC;
wire RESETB_BUF;
wire net12;
wire RESETB;
wire CONVERT;
wire CLK_PGA;
invr_dupe #(.sx(4.8e-07), .GT_PUW(7.2e-07), .GT_PDL(1.8e-07), .lc(2.7e-07), .GT_PUL(1.8e-07), .GT_PDW(4.2e-07)) I6 (.VSS( VSS ), .VDD( VDD ), .in( net12 ), .out( RESETB_BUF ));
invr_dupe #(.sx(4.8e-07), .GT_PUW(7.2e-07), .GT_PDL(1.8e-07), .lc(2.7e-07), .GT_PUL(1.8e-07), .GT_PDW(4.2e-07)) I5 (.VSS( VSS ), .VDD( VDD ), .in( RESETB ), .out( net12 ));
SAR_FSM X_FSM (.clk_pga( CLK_PGA ), .clk_dff( CLK_ADC ), .run_conversion( ENABLE ), .adc_convert( CONVERT ), .adc_resetb( RESETB ), .adc_done( DONE ), .clk( CLK ));
clk_nonoverlapping I8 (.CLK_IN( CLK_PGA ), .VSS( VSS ), .VDD( VDD ), .PHI1( CLK_PGA1 ), .PHI2( CLK_PGA2 ));
SAR_DFF X_SAR (.VDD( VDD ), .VSS( VSS ), .DONE( DONE ), .RESETB( RESETB_BUF ), .D( DAC[7:0] ), .CLK( CLK_ADC ), .COMP( COMP ));

endmodule
// Library - final_project, Cell - zz_EE140_Fa19_digital, View - schematic
// LAST TIME SAVED: Nov 29 01:09:42 2019
// NETLIST TIME: Nov 29 01:12:50 2019

`worklib final_project
`view schematic

`timescale 1ns / 1ps
(* cds_ams_schematic *)

module zz_EE140_Fa19_digital ( );
wire [7:0] D;
wire [0:7] DAC;
wire COMP;
wire CLK;
wire DONE;
wire VDD;
wire CLK_PGA2;
wire ENABLE;
wire CLK_ADC;
wire CLK_PGA1;
EE140_Fa19_digital I33 (.CLK_PGA1( CLK_PGA1 ), .CLK_ADC( CLK_ADC ), .ENABLE( ENABLE ), .CLK_PGA2( CLK_PGA2 ), .VSS(cds_globals.\gnd! ), .VDD( VDD ), .DAC( D[7:0] ), .DONE( DONE ), .CLK( CLK ), .COMP( COMP ));
vsource #(.type("pulse"), .val0(0), .val1(cds_globals.VDD), .rise(cds_globals.TRISE)) V1 (VDD, cds_globals.\gnd! );
vsource #(.type("pulse"), .edgetype("halfsine"), .val0(0), .val1(cds_globals.VDD), .delay(cds_globals.TSTART), .rise(cds_globals.TRISE)) V2 (ENABLE, cds_globals.\gnd! );
vsource #(.type("pulse"), .edgetype("halfsine"), .val0(0), .val1(cds_globals.VCLK), .period(1/cds_globals.FCLK), .rise(cds_globals.TRISE), .fall(cds_globals.TFALL), .width(0.5/cds_globals.FCLK)) V0 (CLK, cds_globals.\gnd! );
vsource #(.dc(cds_globals.VCOMP), .type("dc")) V4 (COMP, cds_globals.\gnd! );

endmodule
`noworklib
`noview
