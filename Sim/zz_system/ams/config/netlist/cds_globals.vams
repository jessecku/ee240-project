// Verilog-AMS cds_globals module for top-level cell:
//    final_project/zz_system.
// Generated by ADE.
// Cadence Design Systems, Inc.

// This is an autoGenerated file, any changes done to this file may get lost.

`include "disciplines.vams"
`include "userDisciplines.vams"

module cds_globals;

// Global Signals
   electrical \gnd! ;
   ground \gnd! ;

// Design Variables
   dynamicparam real vdd = 1.2;
   dynamicparam real vdda = 1.2;
   dynamicparam real vin = 0.4;
   dynamicparam real vref = 1;
   dynamicparam real cap = 100p;
   dynamicparam real VIN_1 = 1;
   dynamicparam real VIN_0 = 0;
   dynamicparam real VBAT = 1.6;
   dynamicparam real TRISE_BAT = 10n;
   dynamicparam real S_1 = 0;
   dynamicparam real S_0 = 0;
   dynamicparam real RBAT = 1;
   dynamicparam real G_2 = 0;
   dynamicparam real G_1 = 0;
   dynamicparam real G_0 = 0;

endmodule
