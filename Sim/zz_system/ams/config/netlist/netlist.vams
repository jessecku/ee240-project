// AMS netlist generated by the AMS Unified netlister
// IC subversion:  IC6.1.7-64b.500.23
// IUS version: 15.20-s076
// Copyright(C) 2005-2009, Cadence Design Systems, Inc
// User: ee140-abd Pid: 721
// Design library name: final_project
// Design cell name: zz_system
// Design view name: config
// Solver: Spectre

`include "disciplines.vams"
`include "userDisciplines.vams"
// HDL file - ee140_gsi, SAR_FSM, functional.
// HDL file - ahdlLib, opamp, veriloga.
// Library - ee140_gsi, Cell - invr_dupe, View - schematic
// LAST TIME SAVED: Nov 19 11:06:49 2019
// NETLIST TIME: Nov 28 16:30:10 2019

`worklib ee140_gsi
`view schematic

`timescale 1ns / 1ps
(* cds_ams_schematic *)

module invr_dupe (out, VDD, VSS, in);
output  out;
input  in;
inout  VDD, VSS;
parameter GT_PDW=0 ;
parameter GT_PDL=1.8e-07 ;
parameter sx=4.8e-07 ;
parameter lc=2.7e-07 ;
parameter GT_PUW=0 ;
parameter GT_PUL=1.8e-07 ;
ne #(.w(GT_PDW), .l(GT_PDL), .as(sx*(GT_PDW)), .ad(sx*(GT_PDW)), .ps(2*(sx+(GT_PDW))), .pd(2*(sx+(GT_PDW))), .nrs(lc/(GT_PDW)), .nrd(lc/(GT_PDW)), .m((1)*(1)), .par1((1)*(1)))
(* integer passed_mfactor = "m"; *)
 ne (out, in, VSS, VSS);
pe #(.w(GT_PUW), .l(GT_PUL), .as(sx*(GT_PUW)), .ad(sx*(GT_PUW)), .ps(2*(sx+(GT_PUW))), .pd(2*(sx+(GT_PUW))), .nrs(lc/(GT_PUW)), .nrd(lc/(GT_PUW)), .m((1)*(1)), .par1((1)*(1)))
(* integer passed_mfactor = "m"; *)
 pe (out, in, VDD, VDD);

endmodule
// Library - ee140_gsi, Cell - NA2HDX0_dupe, View - schematic
// LAST TIME SAVED: Nov 22 13:18:46 2019
// NETLIST TIME: Nov 28 16:30:10 2019

`worklib ee140_gsi
`view schematic

`timescale 1ns / 1ps
(* cds_ams_schematic *)

module NA2HDX0_dupe (Q, VDD, VSS, A, B);
output  Q;
input  A, B;
inout  VDD, VSS;
ne #(.w(4.2e-07), .l(1.8e-07), .as(2.016e-13), .ad(2.016e-13), .ps(1.8e-06), .pd(1.8e-06), .nrs(0.642857), .nrd(0.642857), .m((1)*(1)), .par1((1)*(1)))
(* integer passed_mfactor = "m"; *)
 MN1 (Q, A, net44, VSS);
ne #(.w(4.2e-07), .l(1.8e-07), .as(2.016e-13), .ad(2.016e-13), .ps(1.8e-06), .pd(1.8e-06), .nrs(0.642857), .nrd(0.642857), .m((1)*(1)), .par1((1)*(1)))
(* integer passed_mfactor = "m"; *)
 MN2 (net44, B, VSS, VSS);
pe #(.w(7.2e-07), .l(1.8e-07), .as(3.456e-13), .ad(3.456e-13), .ps(2.4e-06), .pd(2.4e-06), .nrs(0.375), .nrd(0.375), .m((1)*(1)), .par1((1)*(1)))
(* integer passed_mfactor = "m"; *)
 MP1 (Q, A, VDD, VDD);
pe #(.w(7.2e-07), .l(1.8e-07), .as(3.456e-13), .ad(3.456e-13), .ps(2.4e-06), .pd(2.4e-06), .nrs(0.375), .nrd(0.375), .m((1)*(1)), .par1((1)*(1)))
(* integer passed_mfactor = "m"; *)
 MP2 (Q, B, VDD, VDD);

endmodule
// Library - ee140_gsi, Cell - clk_nonoverlapping, View - schematic
// LAST TIME SAVED: Nov 22 13:35:03 2019
// NETLIST TIME: Nov 28 16:30:10 2019

`worklib ee140_gsi
`view schematic

`timescale 1ns / 1ps
(* cds_ams_schematic *)

module clk_nonoverlapping (PHI1, PHI2, VDD, VSS, CLK_IN);
output  PHI1, PHI2;
input  CLK_IN;
inout  VDD, VSS;
wire net08;
wire net09;
wire net5;
wire net3;
wire net2;
wire net1;
wire net4;
invr_dupe #(.sx(4.8e-07), .GT_PUW(7.2e-07), .GT_PDL(1.8e-07), .lc(2.7e-07), .GT_PUL(1.8e-07), .GT_PDW(4.2e-07)) I9 (.VSS( VSS ), .VDD( VDD ), .in( net08 ), .out( PHI2 ));
invr_dupe #(.sx(4.8e-07), .GT_PUW(7.2e-07), .GT_PDL(1.8e-07), .lc(2.7e-07), .GT_PUL(1.8e-07), .GT_PDW(4.2e-07)) I8 (.VSS( VSS ), .VDD( VDD ), .in( net09 ), .out( PHI1 ));
invr_dupe #(.sx(4.8e-07), .GT_PUW(7.2e-07), .GT_PDL(1.8e-07), .lc(2.7e-07), .GT_PUL(1.8e-07), .GT_PDW(4.2e-07)) I6 (.VSS( VSS ), .VDD( VDD ), .in( CLK_IN ), .out( net5 ));
invr_dupe #(.sx(4.8e-07), .GT_PUW(7.2e-07), .GT_PDL(1.8e-07), .lc(2.7e-07), .GT_PUL(1.8e-07), .GT_PDW(4.2e-07)) I5 (.VSS( VSS ), .VDD( VDD ), .in( net3 ), .out( net09 ));
invr_dupe #(.sx(4.8e-07), .GT_PUW(7.2e-07), .GT_PDL(1.8e-07), .lc(2.7e-07), .GT_PUL(1.8e-07), .GT_PDW(4.2e-07)) I4 (.VSS( VSS ), .VDD( VDD ), .in( net2 ), .out( net08 ));
invr_dupe #(.sx(4.8e-07), .GT_PUW(7.2e-07), .GT_PDL(1.8e-07), .lc(2.7e-07), .GT_PUL(1.8e-07), .GT_PDW(4.2e-07)) I3 (.VSS( VSS ), .VDD( VDD ), .in( net1 ), .out( net2 ));
invr_dupe #(.sx(4.8e-07), .GT_PUW(7.2e-07), .GT_PDL(1.8e-07), .lc(2.7e-07), .GT_PUL(1.8e-07), .GT_PDW(4.2e-07)) I2 (.VSS( VSS ), .VDD( VDD ), .in( net4 ), .out( net3 ));
NA2HDX0_dupe I7 (.VSS( VSS ), .VDD( VDD ), .B( net5 ), .Q( net1 ), .A( net09 ));
NA2HDX0_dupe I0 (.VSS( VSS ), .VDD( VDD ), .B( net08 ), .Q( net4 ), .A( CLK_IN ));
capacitor #(.c(1e-13)) C5 (net08, VSS);
capacitor #(.c(1e-13)) C4 (net09, VSS);
capacitor #(.c(1e-13)) C3 (net3, VSS);
capacitor #(.c(1e-13)) C2 (net4, VSS);
capacitor #(.c(1e-13)) C1 (net2, VSS);
capacitor #(.c(1e-13)) C0 (net1, VSS);

endmodule
// Library - ee140_gsi, Cell - DFRRSHDX0_dupe, View - schematic
// LAST TIME SAVED: Nov 19 18:00:26 2019
// NETLIST TIME: Nov 28 16:30:10 2019

`worklib ee140_gsi
`view schematic

`timescale 1ns / 1ps
(* cds_ams_schematic *)

module DFRRSHDX0_dupe (Q, QN, VDD, VSS, C, D, RN, SN);
output  Q, QN;
input  C, D, RN, SN;
inout  VDD, VSS;
wire CIB;
wire SQI;
wire CI;
wire SQIB;
invr_dupe #(.sx(4.8e-07), .GT_PUW(7.2e-07), .GT_PDL(1.8e-07), .lc(2.7e-07), .GT_PUL(1.8e-07), .GT_PDW(4.2e-07)) I0 (.VSS( VSS ), .VDD( VDD ), .in( C ), .out( CIB ));
invr_dupe #(.sx(4.8e-07), .GT_PUW(7.2e-07), .GT_PDL(1.8e-07), .lc(2.7e-07), .GT_PUL(1.8e-07), .GT_PDW(4.2e-07)) I2 (.VSS( VSS ), .VDD( VDD ), .in( SQI ), .out( QN ));
invr_dupe #(.sx(4.8e-07), .GT_PUW(7.2e-07), .GT_PDL(1.8e-07), .lc(2.7e-07), .GT_PUL(1.8e-07), .GT_PDW(4.2e-07)) I1 (.VSS( VSS ), .VDD( VDD ), .in( CIB ), .out( CI ));
invr_dupe #(.sx(4.8e-07), .GT_PUW(7.2e-07), .GT_PDL(1.8e-07), .lc(2.7e-07), .GT_PUL(1.8e-07), .GT_PDW(4.2e-07)) I3 (.VSS( VSS ), .VDD( VDD ), .in( SQIB ), .out( Q ));
ne #(.w(4.2e-07), .l(1.8e-07), .as(2.016e-13), .ad(2.016e-13), .ps(1.8e-06), .pd(1.8e-06), .nrs(0.642857), .nrd(0.642857), .m((1)*(1)), .par1((1)*(1)))
(* integer passed_mfactor = "m"; *)
 MN10 (SQIB, CI, net268, VSS);
ne #(.w(4.2e-07), .l(1.8e-07), .as(2.016e-13), .ad(2.016e-13), .ps(1.8e-06), .pd(1.8e-06), .nrs(0.642857), .nrd(0.642857), .m((1)*(1)), .par1((1)*(1)))
(* integer passed_mfactor = "m"; *)
 MN14 (SQIB, CIB, net266, VSS);
ne #(.w(4.2e-07), .l(1.8e-07), .as(2.016e-13), .ad(2.016e-13), .ps(1.8e-06), .pd(1.8e-06), .nrs(0.642857), .nrd(0.642857), .m((1)*(1)), .par1((1)*(1)))
(* integer passed_mfactor = "m"; *)
 MN2 (MQIB, CIB, net271, VSS);
ne #(.w(4.2e-07), .l(1.8e-07), .as(2.016e-13), .ad(2.016e-13), .ps(1.8e-06), .pd(1.8e-06), .nrs(0.642857), .nrd(0.642857), .m((1)*(1)), .par1((1)*(1)))
(* integer passed_mfactor = "m"; *)
 MN6 (MQIB, CI, net270, VSS);
ne #(.w(4.2e-07), .l(1.8e-07), .as(2.016e-13), .ad(2.016e-13), .ps(1.8e-06), .pd(1.8e-06), .nrs(0.642857), .nrd(0.642857), .m((1)*(1)), .par1((1)*(1)))
(* integer passed_mfactor = "m"; *)
 MN13 (net266, SQI, net265, VSS);
ne #(.w(5.05e-07), .l(1.8e-07), .as(2.424e-13), .ad(2.424e-13), .ps(1.97e-06), .pd(1.97e-06), .nrs(0.534653), .nrd(0.534653), .m((1)*(1)), .par1((1)*(1)))
(* integer passed_mfactor = "m"; *)
 MN7 (MQI, MQIB, net269, VSS);
ne #(.w(8.9e-07), .l(1.8e-07), .as(4.272e-13), .ad(4.272e-13), .ps(2.74e-06), .pd(2.74e-06), .nrs(0.303371), .nrd(0.303371), .m((1)*(1)), .par1((1)*(1)))
(* integer passed_mfactor = "m"; *)
 MN15 (SQI, SQIB, net264, VSS);
ne #(.w(4.2e-07), .l(1.8e-07), .as(2.016e-13), .ad(2.016e-13), .ps(1.8e-06), .pd(1.8e-06), .nrs(0.642857), .nrd(0.642857), .m((1)*(1)), .par1((1)*(1)))
(* integer passed_mfactor = "m"; *)
 MN9 (net268, MQI, net267, VSS);
ne #(.w(4.2e-07), .l(1.8e-07), .as(2.016e-13), .ad(2.016e-13), .ps(1.8e-06), .pd(1.8e-06), .nrs(0.642857), .nrd(0.642857), .m((1)*(1)), .par1((1)*(1)))
(* integer passed_mfactor = "m"; *)
 MN1 (net271, D, net273, VSS);
ne #(.w(4.2e-07), .l(1.8e-07), .as(2.016e-13), .ad(2.016e-13), .ps(1.8e-06), .pd(1.8e-06), .nrs(0.642857), .nrd(0.642857), .m((1)*(1)), .par1((1)*(1)))
(* integer passed_mfactor = "m"; *)
 MN5 (net270, MQI, net272, VSS);
ne #(.w(4.2e-07), .l(1.8e-07), .as(2.016e-13), .ad(2.016e-13), .ps(1.8e-06), .pd(1.8e-06), .nrs(0.642857), .nrd(0.642857), .m((1)*(1)), .par1((1)*(1)))
(* integer passed_mfactor = "m"; *)
 MN11 (net267, RN, VSS, VSS);
ne #(.w(8.9e-07), .l(1.8e-07), .as(4.272e-13), .ad(4.272e-13), .ps(2.74e-06), .pd(2.74e-06), .nrs(0.303371), .nrd(0.303371), .m((1)*(1)), .par1((1)*(1)))
(* integer passed_mfactor = "m"; *)
 MN16 (net264, SN, VSS, VSS);
ne #(.w(4.2e-07), .l(1.8e-07), .as(2.016e-13), .ad(2.016e-13), .ps(1.8e-06), .pd(1.8e-06), .nrs(0.642857), .nrd(0.642857), .m((1)*(1)), .par1((1)*(1)))
(* integer passed_mfactor = "m"; *)
 MN12 (net265, RN, VSS, VSS);
ne #(.w(5.05e-07), .l(1.8e-07), .as(2.424e-13), .ad(2.424e-13), .ps(1.97e-06), .pd(1.97e-06), .nrs(0.534653), .nrd(0.534653), .m((1)*(1)), .par1((1)*(1)))
(* integer passed_mfactor = "m"; *)
 MN8 (net269, SN, VSS, VSS);
ne #(.w(4.2e-07), .l(1.8e-07), .as(2.016e-13), .ad(2.016e-13), .ps(1.8e-06), .pd(1.8e-06), .nrs(0.642857), .nrd(0.642857), .m((1)*(1)), .par1((1)*(1)))
(* integer passed_mfactor = "m"; *)
 MN3 (net273, RN, VSS, VSS);
ne #(.w(4.2e-07), .l(1.8e-07), .as(2.016e-13), .ad(2.016e-13), .ps(1.8e-06), .pd(1.8e-06), .nrs(0.642857), .nrd(0.642857), .m((1)*(1)), .par1((1)*(1)))
(* integer passed_mfactor = "m"; *)
 MN4 (net272, RN, VSS, VSS);
pe #(.w(9.55e-07), .l(1.8e-07), .as(4.584e-13), .ad(4.584e-13), .ps(2.87e-06), .pd(2.87e-06), .nrs(0.282723), .nrd(0.282723), .m((1)*(1)), .par1((1)*(1)))
(* integer passed_mfactor = "m"; *)
 MP3 (MQIB, RN, VDD, VDD);
pe #(.w(9.25e-07), .l(1.8e-07), .as(4.44e-13), .ad(4.44e-13), .ps(2.81e-06), .pd(2.81e-06), .nrs(0.291892), .nrd(0.291892), .m((1)*(1)), .par1((1)*(1)))
(* integer passed_mfactor = "m"; *)
 MP14 (SQI, SN, VDD, VDD);
pe #(.w(5.05e-07), .l(1.8e-07), .as(2.424e-13), .ad(2.424e-13), .ps(1.97e-06), .pd(1.97e-06), .nrs(0.534653), .nrd(0.534653), .m((1)*(1)), .par1((1)*(1)))
(* integer passed_mfactor = "m"; *)
 MP10 (SQIB, RN, VDD, VDD);
pe #(.w(8.5e-07), .l(1.8e-07), .as(4.08e-13), .ad(4.08e-13), .ps(2.66e-06), .pd(2.66e-06), .nrs(0.317647), .nrd(0.317647), .m((1)*(1)), .par1((1)*(1)))
(* integer passed_mfactor = "m"; *)
 MP6 (MQI, MQIB, VDD, VDD);
pe #(.w(7.15e-07), .l(1.8e-07), .as(3.432e-13), .ad(3.432e-13), .ps(2.39e-06), .pd(2.39e-06), .nrs(0.377622), .nrd(0.377622), .m((1)*(1)), .par1((1)*(1)))
(* integer passed_mfactor = "m"; *)
 MP9 (net261, MQI, VDD, VDD);
pe #(.w(8.5e-07), .l(1.8e-07), .as(4.08e-13), .ad(4.08e-13), .ps(2.66e-06), .pd(2.66e-06), .nrs(0.317647), .nrd(0.317647), .m((1)*(1)), .par1((1)*(1)))
(* integer passed_mfactor = "m"; *)
 MP7 (MQI, SN, VDD, VDD);
pe #(.w(9.25e-07), .l(1.8e-07), .as(4.44e-13), .ad(4.44e-13), .ps(2.81e-06), .pd(2.81e-06), .nrs(0.291892), .nrd(0.291892), .m((1)*(1)), .par1((1)*(1)))
(* integer passed_mfactor = "m"; *)
 MP13 (SQI, SQIB, VDD, VDD);
pe #(.w(4.2e-07), .l(1.8e-07), .as(2.016e-13), .ad(2.016e-13), .ps(1.8e-06), .pd(1.8e-06), .nrs(0.642857), .nrd(0.642857), .m((1)*(1)), .par1((1)*(1)))
(* integer passed_mfactor = "m"; *)
 MP12 (net260, SQI, VDD, VDD);
pe #(.w(4.2e-07), .l(1.8e-07), .as(2.016e-13), .ad(2.016e-13), .ps(1.8e-06), .pd(1.8e-06), .nrs(0.642857), .nrd(0.642857), .m((1)*(1)), .par1((1)*(1)))
(* integer passed_mfactor = "m"; *)
 MP5 (net262, MQI, VDD, VDD);
pe #(.w(7.05e-07), .l(1.8e-07), .as(3.384e-13), .ad(3.384e-13), .ps(2.37e-06), .pd(2.37e-06), .nrs(0.382979), .nrd(0.382979), .m((1)*(1)), .par1((1)*(1)))
(* integer passed_mfactor = "m"; *)
 MP2 (net263, D, VDD, VDD);
pe #(.w(4.2e-07), .l(1.8e-07), .as(2.016e-13), .ad(2.016e-13), .ps(1.8e-06), .pd(1.8e-06), .nrs(0.642857), .nrd(0.642857), .m((1)*(1)), .par1((1)*(1)))
(* integer passed_mfactor = "m"; *)
 MP11 (SQIB, CI, net260, VDD);
pe #(.w(4.2e-07), .l(1.8e-07), .as(2.016e-13), .ad(2.016e-13), .ps(1.8e-06), .pd(1.8e-06), .nrs(0.642857), .nrd(0.642857), .m((1)*(1)), .par1((1)*(1)))
(* integer passed_mfactor = "m"; *)
 MP4 (MQIB, CIB, net262, VDD);
pe #(.w(7.15e-07), .l(1.8e-07), .as(3.432e-13), .ad(3.432e-13), .ps(2.39e-06), .pd(2.39e-06), .nrs(0.377622), .nrd(0.377622), .m((1)*(1)), .par1((1)*(1)))
(* integer passed_mfactor = "m"; *)
 MP8 (SQIB, CIB, net261, VDD);
pe #(.w(7.05e-07), .l(1.8e-07), .as(3.384e-13), .ad(3.384e-13), .ps(2.37e-06), .pd(2.37e-06), .nrs(0.382979), .nrd(0.382979), .m((1)*(1)), .par1((1)*(1)))
(* integer passed_mfactor = "m"; *)
 MP1 (MQIB, CI, net263, VDD);

endmodule
// Library - ee140_gsi, Cell - SAR_DFF, View - schematic
// LAST TIME SAVED: Nov 19 18:00:08 2019
// NETLIST TIME: Nov 28 16:30:10 2019

`worklib ee140_gsi
`view schematic

`timescale 1ns / 1ps
(* cds_ams_schematic *)

module SAR_DFF (D, DONE, VDD, VSS, CLK, COMP, RESETB);
output  DONE;
input  CLK, COMP, RESETB;
inout  VDD, VSS;
output [7:0] D;
wire [0:7] X;
wire net010;
wire net019;
wire net014;
wire net067;
wire net018;
wire net025;
wire net022;
wire net029;
wire net026;
wire net033;
wire net030;
wire net065;
wire net034;
wire net043;
wire net038;
wire net048;
wire net2;
wire net053;
wire net09;
DFRRSHDX0_dupe I18 (.VSS( VSS ), .VDD( VDD ), .Q( DONE ), .QN( net019 ), .D( VSS ), .C( VSS ), .SN( net010 ), .RN( RESETB ));
DFRRSHDX0_dupe I17 (.VSS( VSS ), .VDD( VDD ), .Q( D[0] ), .QN( net067 ), .D( COMP ), .C( DONE ), .SN( net014 ), .RN( RESETB ));
DFRRSHDX0_dupe I16 (.VSS( VSS ), .VDD( VDD ), .Q( D[1] ), .QN( net025 ), .D( COMP ), .C( D[0] ), .SN( net018 ), .RN( RESETB ));
DFRRSHDX0_dupe I15 (.VSS( VSS ), .VDD( VDD ), .Q( D[2] ), .QN( net029 ), .D( COMP ), .C( D[1] ), .SN( net022 ), .RN( RESETB ));
DFRRSHDX0_dupe I14 (.VSS( VSS ), .VDD( VDD ), .Q( D[3] ), .QN( net033 ), .D( COMP ), .C( D[2] ), .SN( net026 ), .RN( RESETB ));
DFRRSHDX0_dupe I13 (.VSS( VSS ), .VDD( VDD ), .Q( D[4] ), .QN( net065 ), .D( COMP ), .C( D[3] ), .SN( net030 ), .RN( RESETB ));
DFRRSHDX0_dupe I12 (.VSS( VSS ), .VDD( VDD ), .Q( D[5] ), .QN( net043 ), .D( COMP ), .C( D[4] ), .SN( net034 ), .RN( RESETB ));
DFRRSHDX0_dupe I11 (.VSS( VSS ), .VDD( VDD ), .Q( D[6] ), .QN( net048 ), .D( COMP ), .C( D[5] ), .SN( net038 ), .RN( RESETB ));
DFRRSHDX0_dupe I10 (.VSS( VSS ), .VDD( VDD ), .Q( D[7] ), .QN( net053 ), .D( COMP ), .C( D[6] ), .SN( net2 ), .RN( RESETB ));
DFRRSHDX0_dupe I8 (.VSS( VSS ), .VDD( VDD ), .Q( net09 ), .QN( net010 ), .D( X[0] ), .C( CLK ), .SN( VDD ), .RN( RESETB ));
DFRRSHDX0_dupe I7 (.VSS( VSS ), .VDD( VDD ), .Q( X[0] ), .QN( net014 ), .D( X[1] ), .C( CLK ), .SN( VDD ), .RN( RESETB ));
DFRRSHDX0_dupe I6 (.VSS( VSS ), .VDD( VDD ), .Q( X[1] ), .QN( net018 ), .D( X[2] ), .C( CLK ), .SN( VDD ), .RN( RESETB ));
DFRRSHDX0_dupe I5 (.VSS( VSS ), .VDD( VDD ), .Q( X[2] ), .QN( net022 ), .D( X[3] ), .C( CLK ), .SN( VDD ), .RN( RESETB ));
DFRRSHDX0_dupe I4 (.VSS( VSS ), .VDD( VDD ), .Q( X[3] ), .QN( net026 ), .D( X[4] ), .C( CLK ), .SN( VDD ), .RN( RESETB ));
DFRRSHDX0_dupe I3 (.VSS( VSS ), .VDD( VDD ), .Q( X[4] ), .QN( net030 ), .D( X[5] ), .C( CLK ), .SN( VDD ), .RN( RESETB ));
DFRRSHDX0_dupe I2 (.VSS( VSS ), .VDD( VDD ), .Q( X[5] ), .QN( net034 ), .D( X[6] ), .C( CLK ), .SN( VDD ), .RN( RESETB ));
DFRRSHDX0_dupe I1 (.VSS( VSS ), .VDD( VDD ), .Q( X[6] ), .QN( net038 ), .D( X[7] ), .C( CLK ), .SN( VDD ), .RN( RESETB ));
DFRRSHDX0_dupe I0 (.VSS( VSS ), .VDD( VDD ), .Q( X[7] ), .QN( net2 ), .D( VSS ), .C( CLK ), .SN( RESETB ), .RN( VDD ));

endmodule
// Library - ee140_gsi, Cell - EE140_Fa19_digital, View - schematic
// LAST TIME SAVED: Nov 22 13:41:36 2019
// NETLIST TIME: Nov 28 16:30:10 2019

`worklib ee140_gsi
`view schematic

`timescale 1ns / 1ps
(* cds_ams_schematic *)

module EE140_Fa19_digital (CLK_ADC, CLK_PGA1, CLK_PGA2, DAC, DONE, VDD, VSS, CLK, COMP, ENABLE);
output  CLK_ADC, CLK_PGA1, CLK_PGA2, DONE;
input  CLK, COMP, ENABLE;
inout  VDD, VSS;
output [7:0] DAC;
wire RESETB_BUF;
wire net12;
wire RESETB;
wire CONVERT;
wire CLK_PGA;
invr_dupe #(.sx(4.8e-07), .GT_PUW(7.2e-07), .GT_PDL(1.8e-07), .lc(2.7e-07), .GT_PUL(1.8e-07), .GT_PDW(4.2e-07)) I6 (.VSS( VSS ), .VDD( VDD ), .in( net12 ), .out( RESETB_BUF ));
invr_dupe #(.sx(4.8e-07), .GT_PUW(7.2e-07), .GT_PDL(1.8e-07), .lc(2.7e-07), .GT_PUL(1.8e-07), .GT_PDW(4.2e-07)) I5 (.VSS( VSS ), .VDD( VDD ), .in( RESETB ), .out( net12 ));
SAR_FSM X_FSM (.clk_pga( CLK_PGA ), .clk_dff( CLK_ADC ), .run_conversion( ENABLE ), .adc_convert( CONVERT ), .adc_resetb( RESETB ), .adc_done( DONE ), .clk( CLK ));
clk_nonoverlapping X_PGACLKGEN (.CLK_IN( CLK_PGA ), .VSS( VSS ), .VDD( VDD ), .PHI1( CLK_PGA1 ), .PHI2( CLK_PGA2 ));
SAR_DFF X_SAR (.VDD( VDD ), .VSS( VSS ), .DONE( DONE ), .RESETB( RESETB_BUF ), .D( DAC[7:0] ), .CLK( CLK_ADC ), .COMP( COMP ));

endmodule
// Library - final_project, Cell - inverter, View - schematic
// LAST TIME SAVED: Nov 24 23:08:27 2019
// NETLIST TIME: Nov 28 16:30:10 2019

`worklib final_project
`view schematic

`timescale 1ns / 1ps
(* cds_ams_schematic *)

module inverter (OUT, VDD, VSS, IN);
output  OUT;
input  IN;
inout  VDD, VSS;
ne #(.w(2.2e-07), .l(1.8e-07), .as(1.056e-13), .ad(1.056e-13), .ps(1.4e-06), .pd(1.4e-06), .nrs(1.22727), .nrd(1.22727), .m((1)*(1)), .par1((1)*(1)))
(* integer passed_mfactor = "m"; *)
 M0 (OUT, IN, VSS, VSS);
pe #(.w(2.2e-07), .l(1.8e-07), .as(1.056e-13), .ad(1.056e-13), .ps(1.4e-06), .pd(1.4e-06), .nrs(1.22727), .nrd(1.22727), .m((1)*(1)), .par1((1)*(1)))
(* integer passed_mfactor = "m"; *)
 M1 (OUT, IN, VDD, VDD);

endmodule
// Library - final_project, Cell - SR_latch, View - schematic
// LAST TIME SAVED: Nov 26 15:29:08 2019
// NETLIST TIME: Nov 28 16:30:10 2019

`worklib final_project
`view schematic

`timescale 1ns / 1ps
(* cds_ams_schematic *)

module SR_latch (out, VDD, VSS, X, Y);
output  out;
input  X, Y;
inout  VDD, VSS;
wire net11;
wire net12;
wire net7;
inverter I3 (.IN( Y ), .VSS( VSS ), .VDD( VDD ), .OUT( net11 ));
inverter I2 (.IN( X ), .VSS( VSS ), .VDD( VDD ), .OUT( net12 ));
inverter I1 (.IN( out ), .VSS( VSS ), .VDD( VDD ), .OUT( net7 ));
inverter I0 (.IN( net7 ), .VSS( VSS ), .VDD( VDD ), .OUT( out ));
ne #(.w(2.2e-07), .l(1.8e-07), .as(1.056e-13), .ad(1.056e-13), .ps(1.4e-06), .pd(1.4e-06), .nrs(1.22727), .nrd(1.22727), .m((1)*(1)), .par1((1)*(1)))
(* integer passed_mfactor = "m"; *)
 M1 (out, net11, VSS, VSS);
ne #(.w(2.2e-07), .l(1.8e-07), .as(1.056e-13), .ad(1.056e-13), .ps(1.4e-06), .pd(1.4e-06), .nrs(1.22727), .nrd(1.22727), .m((1)*(1)), .par1((1)*(1)))
(* integer passed_mfactor = "m"; *)
 M0 (net7, net12, VSS, VSS);

endmodule
// Library - final_project, Cell - DREG, View - schematic
// LAST TIME SAVED: Nov 24 20:15:42 2019
// NETLIST TIME: Nov 28 16:30:10 2019

`worklib final_project
`view schematic

`timescale 1ns / 1ps
(* cds_ams_schematic *)

module DREG (VDDD, VBAT, VSS, VREF);
output  VDDD;
input  VREF;
inout  VBAT, VSS;

endmodule
// Library - final_project, Cell - VBATDIV4, View - schematic
// LAST TIME SAVED: Nov 24 20:14:58 2019
// NETLIST TIME: Nov 28 16:30:10 2019

`worklib final_project
`view schematic

`timescale 1ns / 1ps
(* cds_ams_schematic *)

module VBATDIV4 (VBATDIV4, VBAT, VSS);
output  VBATDIV4;
inout  VBAT, VSS;

endmodule
// Library - final_project, Cell - system, View - schematic
// LAST TIME SAVED: Nov 27 11:34:53 2019
// NETLIST TIME: Nov 28 16:30:10 2019

`worklib final_project
`view schematic

`timescale 1ns / 1ps
(* cds_ams_schematic *)

module system (COMP, VDDA, VDDD, VBAT, VSS, CLK_ADC, CLK_PGA1, CLK_PGA2, D, EXT_IN[0], EXT_IN[1], G, S);
output  COMP, VDDA, VDDD;
input  CLK_ADC, CLK_PGA1, CLK_PGA2;
inout  VBAT, VSS;
input [1:0] S;
input [2:0] G;
input [0:1] EXT_IN;
input [7:0] D;
wire VREF_ADC;
wire VIN;
wire net4;
wire net015;
wire VPTAT;
wire VBATDIV4;
wire VREF_REG;
wire net012;
ADC I8 (.CMP( CLK_PGA2 ), .LD( CLK_PGA1 ), .VSS( VSS ), .VDD( VDDA ), .COMP_OUT( COMP ), .D( D[7:0] ), .VIN( VIN ), .VREF( VREF_ADC ), .CLK( CLK_ADC ));
PGA I9 (.G( G[2:0] ), .VSS( VSS ), .VDD( VDDA ), .VOUT( net015 ), .CLK( CLK_PGA1 ), .VIN( net4 ));
mux I10 ( net4 ,  VDDA ,  VSS ,  EXT_IN[0] ,  EXT_IN[1] ,  VBATDIV4 ,  VPTAT ,  S[1:0] );
BGR I12 (.VBAT( VBAT ), .VSS( VSS ), .VREF_ADC( VREF_ADC ), .VBG( VREF_REG ), .VPTAT( VPTAT ));
AREG I13 (.VSS( VSS ), .VBAT( VBAT ), .VDDA( net012 ), .VREF( VREF_REG ));
DREG I14 (.VDDD( VDDD ), .VSS( VSS ), .VBAT( VBAT ), .VREF( VREF_REG ));
VBATDIV4 I11 (.VSS( VSS ), .VBAT( VBAT ), .VBATDIV4( VBATDIV4 ));
vsource #(.type("pulse"), .val0(0), .val1(cds_globals.vin), .rise(cds_globals.TRISE_BAT)) V2 (net011, VSS);
vsource #(.type("pulse"), .val0(0), .val1(cds_globals.vref), .rise(cds_globals.TRISE_BAT)) V1 (net019, VSS);
vsource #(.type("pulse"), .val0(0), .val1(cds_globals.vdda), .rise(cds_globals.TRISE_BAT)) V0 (net013, VSS);
resistor #(.r(cds_globals.RBAT)) R2 (VIN, net011);
resistor #(.r(cds_globals.RBAT)) R1 (VREF_ADC, net019);
resistor #(.r(cds_globals.RBAT)) R0 (VDDA, net013);

endmodule
// Library - final_project, Cell - zz_system, View - schematic
// LAST TIME SAVED: Nov 26 19:00:11 2019
// NETLIST TIME: Nov 28 16:30:10 2019

`worklib final_project
`view schematic

`timescale 1ns / 1ps
(* cds_ams_schematic *)

module zz_system ( );
wire [7:0] D;
wire [0:1] EXT_IN;
wire [1:0] S;
wire [2:0] G;
wire PHI2_temp;
wire PHI1_temp;
wire CLK_ADC;
wire VBAT;
wire VDDD;
wire VDDA;
wire COMP;
wire CLK;
wire DONE;
wire CLK_PGA2;
wire CLK_PGA1;
system I27 ( COMP ,  VDDA ,  VDDD ,  VBAT , cds_globals.\gnd! ,  CLK_ADC ,  PHI1_temp ,  PHI2_temp ,  D[7:0] ,  EXT_IN[0] ,  EXT_IN[1] ,  G[2:0] ,  S[1:0] );
EE140_Fa19_digital X_GSI (.CLK_PGA1( CLK_PGA1 ), .CLK_PGA2( CLK_PGA2 ), .CLK_ADC( CLK_ADC ), .ENABLE( VDDA ), .VSS(cds_globals.\gnd! ), .VDD( VDDA ), .DAC( D[7:0] ), .DONE( DONE ), .CLK( CLK ), .COMP( COMP ));
vsource #(.type("pulse"), .val0(0), .val1(cds_globals.vdda), .delay(2e-06), .rise(1e-08)) V9 (PHI2_temp, cds_globals.\gnd! );
vsource #(.type("pulse"), .val0(0), .val1(cds_globals.vdda), .rise(1e-08), .fall(1e-08), .width(2e-06)) V8 (PHI1_temp, cds_globals.\gnd! );
vsource #(.type("pulse"), .edgetype("halfsine"), .val0(0), .val1(cds_globals.VBAT), .rise(cds_globals.TRISE_BAT)) V3 (net1, cds_globals.\gnd! );
vsource #(.type("pulse"), .edgetype("halfsine"), .val0(0), .val1(1.8), .period(1e-06), .rise(1e-08), .fall(1e-08), .width(5e-07)) V1 (CLK, cds_globals.\gnd! );
isource #(.type("pulse"), .val0(0.001), .val1(0.005), .period(1e-07), .delay(1e-08), .rise(1e-08), .fall(1e-08), .width(3e-08)) I22 (VDDD, cds_globals.\gnd! );
vcvs #(.gain(cds_globals.S_0)) E1 (S[0], cds_globals.\gnd! , VDDD, cds_globals.\gnd! );
vcvs #(.gain(cds_globals.S_1), .type("vcvs")) E0 (S[1], cds_globals.\gnd! , VDDD, cds_globals.\gnd! );
vcvs #(.gain(cds_globals.G_1)) E3 (G[1], cds_globals.\gnd! , VDDD, cds_globals.\gnd! );
vcvs #(.gain(cds_globals.G_0)) E2 (G[0], cds_globals.\gnd! , VDDD, cds_globals.\gnd! );
vcvs #(.gain(cds_globals.G_2)) E4 (G[2], cds_globals.\gnd! , VDDD, cds_globals.\gnd! );
resistor #(.r(cds_globals.RBAT)) R0 (VBAT, net1);
capacitor #(.c(1e-09)) C0 (VDDD, cds_globals.\gnd! );
vsource #(.dc(cds_globals.VIN_0), .type("dc")) V2 (EXT_IN[0], cds_globals.\gnd! );
vsource #(.dc(cds_globals.VIN_1), .type("dc")) V0 (EXT_IN[1], cds_globals.\gnd! );

endmodule
// Library - final_project, Cell - COMP, View - schematic
// LAST TIME SAVED: Nov 27 00:20:42 2019
// NETLIST TIME: Nov 28 16:30:10 2019

`worklib final_project
`view schematic

`timescale 1ns / 1ps
(* cds_ams_schematic *)

module COMP (OUT, VDD, VSS, CLK, INN, INP);
output  OUT;
input  CLK, INN, INP;
inout  VDD, VSS;
wire Y;
wire X;
SR_latch I9 (.VSS( VSS ), .VDD( VDD ), .out( OUT ), .X( X ), .Y( Y ));
pe #(.w(2.2e-07), .l(1.8e-07), .as(1.056e-13), .ad(1.056e-13), .ps(1.4e-06), .pd(1.4e-06), .nrs(1.22727), .nrd(1.22727), .m((1)*(1)), .par1((1)*(1)))
(* integer passed_mfactor = "m"; *)
 S2 (Q, CLK, VDD, VDD);
pe #(.w(2.2e-07), .l(1.8e-07), .as(1.056e-13), .ad(1.056e-13), .ps(1.4e-06), .pd(1.4e-06), .nrs(1.22727), .nrd(1.22727), .m((1)*(1)), .par1((1)*(1)))
(* integer passed_mfactor = "m"; *)
 S4 (Y, CLK, VDD, VDD);
pe #(.w(2.2e-07), .l(1.8e-07), .as(1.056e-13), .ad(1.056e-13), .ps(1.4e-06), .pd(1.4e-06), .nrs(1.22727), .nrd(1.22727), .m((1)*(1)), .par1((1)*(1)))
(* integer passed_mfactor = "m"; *)
 M3L (X, Y, VDD, VDD);
pe #(.w(2.2e-07), .l(1.8e-07), .as(1.056e-13), .ad(1.056e-13), .ps(1.4e-06), .pd(1.4e-06), .nrs(1.22727), .nrd(1.22727), .m((1)*(1)), .par1((1)*(1)))
(* integer passed_mfactor = "m"; *)
 S1 (P, CLK, VDD, VDD);
pe #(.w(2.2e-07), .l(1.8e-07), .as(1.056e-13), .ad(1.056e-13), .ps(1.4e-06), .pd(1.4e-06), .nrs(1.22727), .nrd(1.22727), .m((1)*(1)), .par1((1)*(1)))
(* integer passed_mfactor = "m"; *)
 S3 (X, CLK, VDD, VDD);
pe #(.w(2.2e-07), .l(1.8e-07), .as(1.056e-13), .ad(1.056e-13), .ps(1.4e-06), .pd(1.4e-06), .nrs(1.22727), .nrd(1.22727), .m((1)*(1)), .par1((1)*(1)))
(* integer passed_mfactor = "m"; *)
 M3R (Y, X, VDD, VDD);
ne #(.w(2.2e-07), .l(1.8e-07), .as(1.056e-13), .ad(1.056e-13), .ps(1.4e-06), .pd(1.4e-06), .nrs(1.22727), .nrd(1.22727), .m((1)*(1)), .par1((1)*(1)))
(* integer passed_mfactor = "m"; *)
 S5 (net15, CLK, VSS, VSS);
ne #(.w(2.2e-07), .l(1.8e-07), .as(1.056e-13), .ad(1.056e-13), .ps(1.4e-06), .pd(1.4e-06), .nrs(1.22727), .nrd(1.22727), .m((1)*(1)), .par1((1)*(1)))
(* integer passed_mfactor = "m"; *)
 M1R (Q, INN, net15, net15);
ne #(.w(2.2e-07), .l(1.8e-07), .as(1.056e-13), .ad(1.056e-13), .ps(1.4e-06), .pd(1.4e-06), .nrs(1.22727), .nrd(1.22727), .m((1)*(1)), .par1((1)*(1)))
(* integer passed_mfactor = "m"; *)
 M1L (P, INP, net15, net15);
ne #(.w(2.2e-07), .l(1.8e-07), .as(1.056e-13), .ad(1.056e-13), .ps(1.4e-06), .pd(1.4e-06), .nrs(1.22727), .nrd(1.22727), .m((1)*(1)), .par1((1)*(1)))
(* integer passed_mfactor = "m"; *)
 M2R (Y, X, Q, Q);
ne #(.w(2.2e-07), .l(1.8e-07), .as(1.056e-13), .ad(1.056e-13), .ps(1.4e-06), .pd(1.4e-06), .nrs(1.22727), .nrd(1.22727), .m((1)*(1)), .par1((1)*(1)))
(* integer passed_mfactor = "m"; *)
 M2L (X, Y, P, P);

endmodule
// Library - final_project, Cell - mux2, View - schematic
// LAST TIME SAVED: Nov 27 00:18:59 2019
// NETLIST TIME: Nov 28 16:30:10 2019

`worklib final_project
`view schematic

`timescale 1ns / 1ps
(* cds_ams_schematic *)

module mux2 (out, VDD, VSS, S, in0, in1);
output  out;
input  in0, in1;
inout  VDD, VSS;
input [0:0] S;
wire net8;
inverter I0 (.IN( S[0] ), .VSS( VSS ), .VDD( VDD ), .OUT( net8 ));
relay #(.vt1(0.1), .vt2(0.9), .ropen(1e+12), .rclosed(1)) W1 (in0, out, net8, VSS);
relay #(.vt1(0.1), .vt2(0.9), .ropen(1e+12), .rclosed(1)) W0 (in1, out, S[0], VSS);

endmodule
// Library - final_project, Cell - ADC_ctrl, View - schematic
// LAST TIME SAVED: Nov 25 10:14:02 2019
// NETLIST TIME: Nov 28 16:30:10 2019

`worklib final_project
`view schematic

`timescale 1ns / 1ps
(* cds_ams_schematic *)

module ADC_ctrl (B, VDD, VSS, S, VREF);
input  VREF;
inout  VDD, VSS;
output [7:0] B;
input [7:0] S;
mux2 I5 (.S( S[5] ), .VSS( VSS ), .VDD( VDD ), .out( B[5] ), .in0( VSS ), .in1( VREF ));
mux2 I7 (.S( S[7] ), .VSS( VSS ), .VDD( VDD ), .out( B[7] ), .in0( VSS ), .in1( VREF ));
mux2 I4 (.S( S[4] ), .VSS( VSS ), .VDD( VDD ), .out( B[4] ), .in0( VSS ), .in1( VREF ));
mux2 I1 (.S( S[1] ), .VSS( VSS ), .VDD( VDD ), .out( B[1] ), .in0( VSS ), .in1( VREF ));
mux2 I3 (.S( S[3] ), .VSS( VSS ), .VDD( VDD ), .out( B[3] ), .in0( VSS ), .in1( VREF ));
mux2 I6 (.S( S[6] ), .VSS( VSS ), .VDD( VDD ), .out( B[6] ), .in0( VSS ), .in1( VREF ));
mux2 I2 (.S( S[2] ), .VSS( VSS ), .VDD( VDD ), .out( B[2] ), .in0( VSS ), .in1( VREF ));
mux2 I0 (.S( S[0] ), .VSS( VSS ), .VDD( VDD ), .out( B[0] ), .in0( VSS ), .in1( VREF ));

endmodule
// Library - final_project, Cell - ADC, View - schematic
// LAST TIME SAVED: Nov 27 10:51:58 2019
// NETLIST TIME: Nov 28 16:30:10 2019

`worklib final_project
`view schematic

`timescale 1ns / 1ps
(* cds_ams_schematic *)

module ADC (COMP_OUT, VDD, VSS, CLK, CMP, D, LD, VIN, VREF);
output  COMP_OUT;
input  CLK, CMP, LD, VIN, VREF;
inout  VDD, VSS;
input [7:0] D;
wire [7:0] B;
wire ADC_INN;
wire net017;
COMP I1 (.CLK( net017 ), .VSS( VSS ), .VDD( VDD ), .OUT( COMP_OUT ), .INP( VREF ), .INN( ADC_INN ));
ADC_ctrl I7 (.VSS( VSS ), .VREF( VREF ), .VDD( VDD ), .B( B[7:0] ), .S( D[7:0] ));
inverter I8 (.IN( CLK ), .VSS( VSS ), .VDD( VDD ), .OUT( net017 ));
relay #(.ropen(1e+12), .rclosed(1)) W21 (net05, B[6], CMP, VSS);
relay #(.ropen(1e+12), .rclosed(1)) W20 (net05, VIN, LD, VSS);
relay #(.ropen(1e+12), .rclosed(1)) W19 (net04, VIN, LD, VSS);
relay #(.ropen(1e+12), .rclosed(1)) W18 (net04, B[7], CMP, VSS);
relay #(.ropen(1e+12), .rclosed(1)) W17 (net07, B[4], CMP, VSS);
relay #(.ropen(1e+12), .rclosed(1)) W16 (net07, VIN, LD, VSS);
relay #(.ropen(1e+12), .rclosed(1)) W15 (net06, VIN, LD, VSS);
relay #(.ropen(1e+12), .rclosed(1)) W14 (net06, B[5], CMP, VSS);
relay #(.ropen(1e+12), .rclosed(1)) W13 (net08, B[3], CMP, VSS);
relay #(.ropen(1e+12), .rclosed(1)) W12 (net08, VIN, LD, VSS);
relay #(.ropen(1e+12), .rclosed(1)) W9 (net010, B[1], CMP, VSS);
relay #(.ropen(1e+12), .rclosed(1)) W8 (net010, VIN, LD, VSS);
relay #(.ropen(1e+12), .rclosed(1)) W22 (net071, VIN, LD, VSS);
relay #(.ropen(1e+12), .rclosed(1)) W11 (net09, VIN, LD, VSS);
relay #(.ropen(1e+12), .rclosed(1)) W10 (net09, B[2], CMP, VSS);
relay #(.ropen(1e+12), .rclosed(1)) W3 (net26, B[0], CMP, VSS);
relay #(.ropen(1e+12), .rclosed(1)) W2 (net26, VIN, LD, VSS);
relay #(.ropen(1e+12), .rclosed(1)) W23 (net071, VSS, CMP, VSS);
relay #(.ropen(1e+12), .rclosed(1)) W0 (VREF, ADC_INN, LD, VSS);
capacitor #(.c(cds_globals.cap)) C0 (ADC_INN, net071);
capacitor #(.c(128*cds_globals.cap)) C8 (ADC_INN, net04);
capacitor #(.c(64*cds_globals.cap)) C7 (ADC_INN, net05);
capacitor #(.c(8*cds_globals.cap)) C4 (ADC_INN, net08);
capacitor #(.c(32*cds_globals.cap)) C6 (ADC_INN, net06);
capacitor #(.c(16*cds_globals.cap)) C5 (ADC_INN, net07);
capacitor #(.c(cds_globals.cap)) C1 (ADC_INN, net26);
capacitor #(.c(4*cds_globals.cap)) C3 (ADC_INN, net09);
capacitor #(.c(2*cds_globals.cap)) C2 (ADC_INN, net010);

endmodule
// Library - final_project, Cell - PGA, View - schematic
// LAST TIME SAVED: Nov 28 16:28:35 2019
// NETLIST TIME: Nov 28 16:30:10 2019

`worklib final_project
`view schematic

`timescale 1ns / 1ps
(* cds_ams_schematic *)

module PGA (VOUT, VDD, VSS, CLK, G, VIN);
output  VOUT;
input  CLK, VIN;
inout  VDD, VSS;
input [2:0] G;
wire net017;
wire net9;
wire CLK2;
opamp #(.freq_unitygain(100000000.0), .gain(2000)) I0 (.vin_p( VSS ), .vin_n( net9 ), .vout( VOUT ), .vspply_p( VDD ), .vref( net017 ), .vspply_n( VSS ));
inverter I3 (.IN( CLK ), .VSS( VSS ), .VDD( VDD ), .OUT( CLK2 ));
resistor #(.r(100000)) R0 (VOUT, VSS);
capacitor #(.c(4e-11)) C4 (net9, VOUT);
capacitor #(.c(4e-10)) C0 (net014, net9);
vsource #(.dc(1.2), .type("dc")) V1 (VDD, VSS);
vsource #(.dc(0.05), .mag(0.1), .type("dc")) V0 (VIN, VSS);
relay #(.ropen(1e+12), .rclosed(1)) W1 (VIN, VSS, CLK2, VSS);
relay #(.ropen(1e+12), .rclosed(1)) W0 (net014, VIN, CLK, VSS);
relay #(.ropen(1e+12), .rclosed(1)) W21 (VOUT, net9, CLK2, VSS);

endmodule
// Library - final_project, Cell - mux, View - schematic
// LAST TIME SAVED: Nov 27 16:06:06 2019
// NETLIST TIME: Nov 28 16:30:10 2019

`worklib final_project
`view schematic

`timescale 1ns / 1ps
(* cds_ams_schematic *)

module mux (OUT, VDD, VSS, IN[0], IN[1], IN[2], IN[3], S);
output  OUT;
inout  VDD, VSS;
input [1:0] S;
input [3:0] IN;
wire net10;
wire net11;
mux2 I2 (.S( S[1] ), .VSS( VSS ), .VDD( VDD ), .out( OUT ), .in0( net11 ), .in1( net10 ));
mux2 I1 (.S( S[0] ), .VSS( VSS ), .VDD( VDD ), .out( net10 ), .in0( IN[1] ), .in1( IN[0] ));
mux2 I0 (.S( S[0] ), .VSS( VSS ), .VDD( VDD ), .out( net11 ), .in0( IN[3] ), .in1( IN[2] ));

endmodule
// Library - final_project, Cell - BGR, View - schematic
// LAST TIME SAVED: Nov 24 20:14:13 2019
// NETLIST TIME: Nov 28 16:30:10 2019

`worklib final_project
`view schematic

`timescale 1ns / 1ps
(* cds_ams_schematic *)

module BGR (VBG, VPTAT, VREF_ADC, VBAT, VSS);
output  VBG, VPTAT, VREF_ADC;
inout  VBAT, VSS;

endmodule
// Library - final_project, Cell - AREG, View - schematic
// LAST TIME SAVED: Nov 24 20:13:58 2019
// NETLIST TIME: Nov 28 16:30:10 2019

`worklib final_project
`view schematic

`timescale 1ns / 1ps
(* cds_ams_schematic *)

module AREG (VDDA, VBAT, VSS, VREF);
output  VDDA;
input  VREF;
inout  VBAT, VSS;

endmodule
`noworklib
`noview
