// -----------------------------------------------------------------------------
// (c) Copyright 2010 Cadence Design Systems, Inc. All rights reserved worldwide.
// -----------------------------------------------------------------------------

// Binding AMSD Control Block for config final_project.zz_system:config
// Created On: Nov 28 16:30:13 2019
// NOTE      : DO NOT change this system generated file.

amsd {
	config designtop="final_project.zz_system:schematic"

	config cell="mux2" lib="final_project" view="schematic"
	config cell="SAR_DFF" lib="ee140_gsi" view="schematic"
	config cell="opamp" lib="ahdlLib" view="veriloga" stopview="yes"
	config cell="pe" view="analogtext"
	config cell="capacitor" view="analogtext"
	config cell="BGR" lib="final_project" view="schematic"
	config cell="vsource" view="analogtext"
	config cell="PGA" lib="final_project" view="schematic"
	config cell="EE140_Fa19_digital" lib="ee140_gsi" view="schematic"
	config cell="SR_latch" lib="final_project" view="schematic"
	config cell="SAR_FSM" lib="ee140_gsi" view="functional"
	config cell="ne" view="analogtext"
	config cell="inverter" lib="final_project" view="schematic"
	config cell="NA2HDX0_dupe" lib="ee140_gsi" view="schematic"
	config cell="isource" view="analogtext"
	config cell="DREG" lib="final_project" view="schematic"
	config cell="resistor" view="analogtext"
	config cell="clk_nonoverlapping" lib="ee140_gsi" view="schematic"
	config cell="invr_dupe" lib="ee140_gsi" view="schematic"
	config cell="system" lib="final_project" view="schematic"
	config cell="ADC_ctrl" lib="final_project" view="schematic"
	config cell="AREG" lib="final_project" view="schematic"
	config cell="VBATDIV4" lib="final_project" view="schematic"
	config cell="ADC" lib="final_project" view="schematic"
	config cell="COMP" lib="final_project" view="schematic"
	config cell="vcvs" view="analogtext"
	config cell="DFRRSHDX0_dupe" lib="ee140_gsi" view="schematic"
	config cell="mux" lib="final_project" view="schematic"
	config cell="relay" view="analogtext"

 }
