// Design: final_project/zz_ADC
simulator lang=spectre
global 0
parameters d0=0 d1=0 d2=0 d3=0 d4=0 d5=0 d6=0 d7=0 supply=1.2 ref=1 vin=400m cap=100p
include "/home/ff/ee140/fa19/xfab/XKIT/xt018/cadence/v8_0/spectre/v8_0_2/lp5mos/config.scs" section=default
include "/home/ff/ee140/fa19/xfab/XKIT/xt018/cadence/v8_0/spectre/v8_0_2/lp5mos/param.scs" section=3s
include "/home/ff/ee140/fa19/xfab/XKIT/xt018/cadence/v8_0/spectre/v8_0_2/lp5mos/bip.scs" section=tm
include "/home/ff/ee140/fa19/xfab/XKIT/xt018/cadence/v8_0/spectre/v8_0_2/lp5mos/cap.scs" section=tm
include "/home/ff/ee140/fa19/xfab/XKIT/xt018/cadence/v8_0/spectre/v8_0_2/lp5mos/dio.scs" section=tm
include "/home/ff/ee140/fa19/xfab/XKIT/xt018/cadence/v8_0/spectre/v8_0_2/lp5mos/mos.scs" section=tm
include "/home/ff/ee140/fa19/xfab/XKIT/xt018/cadence/v8_0/spectre/v8_0_2/lp5mos/res.scs" section=tm

// final_project/inverter/schematic
subckt inverter IN OUT VDD VSS
    M0 (OUT IN VSS VSS) ne w=220.0n l=180.0n m=(1)*(1)
    M1 (OUT IN VDD VDD) pe w=220.0n l=180.0n m=(1)*(1)
ends inverter

// final_project/sw_pmos/schematic
subckt sw_pmos VSS io0 io1 sw_ctrl VDD
    I0 (sw_ctrl net13 VDD VSS) inverter
    M0 (io1 net13 io0 VDD) pe w=220.0n l=180.0n m=(1)*(1)
ends sw_pmos

// final_project/SR_latch/schematic
subckt SR_latch VDD VSS X Y out
    I3 (Y net11 VDD VSS) inverter
    I2 (X net12 VDD VSS) inverter
    I1 (out net7 VDD VSS) inverter
    I0 (net7 out VDD VSS) inverter
    M1 (out net11 VSS VSS) ne w=220.0n l=180.0n m=(1)*(1)
    M0 (net7 net12 VSS VSS) ne w=220.0n l=180.0n m=(1)*(1)
ends SR_latch

// final_project/COMP/schematic
subckt COMP INN INP OUT VDD VSS CLK
    S2 (Q CLK VDD VDD) pe w=220.0n l=180.0n m=(1)*(1)
    S4 (Y CLK VDD VDD) pe w=220.0n l=180.0n m=(1)*(1)
    M3L (X Y VDD VDD) pe w=220.0n l=180.0n m=(1)*(1)
    S1 (P CLK VDD VDD) pe w=220.0n l=180.0n m=(1)*(1)
    S3 (X CLK VDD VDD) pe w=220.0n l=180.0n m=(1)*(1)
    M3R (Y X VDD VDD) pe w=220.0n l=180.0n m=(1)*(1)
    S5 (net15 CLK VSS VSS) ne w=220.0n l=180.0n m=(1)*(1)
    M1R (Q INN net15 net15) ne w=220.0n l=180.0n m=(1)*(1)
    M1L (P INP net15 net15) ne w=220.0n l=180.0n m=(1)*(1)
    M2R (Y X Q Q) ne w=220.0n l=180.0n m=(1)*(1)
    M2L (X Y P P) ne w=220.0n l=180.0n m=(1)*(1)
    I9 (VDD VSS X Y OUT) SR_latch
ends COMP

// final_project/sw_cmos/schematic
subckt sw_cmos VDD VSS io0 io1 sw_ctrl
    M0 (io0 sw_ctrl io1 VSS) ne w=220.0n l=180.0n m=(1)*(1)
    M1 (io0 sw_ctrl_bar io1 VDD) pe w=220.0n l=180.0n m=(1)*(1)
    I0 (sw_ctrl sw_ctrl_bar VDD VSS) inverter
ends sw_cmos

// final_project/mux2/schematic
subckt mux2 S\<0\> VDD VSS in0 in1 out
    I0 (S\<0\> net8 VDD VSS) inverter
    I2 (VDD VSS in0 out net8) sw_cmos
    I1 (VDD VSS in1 out S\<0\>) sw_cmos
ends mux2

// final_project/ADC_ctrl/schematic
subckt ADC_ctrl B\<7\> B\<6\> B\<5\> B\<4\> B\<3\> B\<2\> B\<1\> B\<0\> S\<7\> S\<6\> S\<5\> S\<4\> S\<3\> S\<2\> S\<1\> S\<0\> VDD VREF VSS
    I5 (S\<5\> VDD VSS VSS VREF B\<5\>) mux2
    I7 (S\<7\> VDD VSS VSS VREF B\<7\>) mux2
    I4 (S\<4\> VDD VSS VSS VREF B\<4\>) mux2
    I1 (S\<1\> VDD VSS VSS VREF B\<1\>) mux2
    I3 (S\<3\> VDD VSS VSS VREF B\<3\>) mux2
    I6 (S\<6\> VDD VSS VSS VREF B\<6\>) mux2
    I2 (S\<2\> VDD VSS VSS VREF B\<2\>) mux2
    I0 (S\<0\> VDD VSS VSS VREF B\<0\>) mux2
ends ADC_ctrl

// final_project/ADC/schematic
subckt ADC CLK COMP_OUT D\<7\> D\<6\> D\<5\> D\<4\> D\<3\> D\<2\> D\<1\> D\<0\> VDD VIN VREF VSS CMP LD
    I29 (VSS VREF ADC_INN LD VDD) sw_pmos
    C0 (ADC_INN net071) capacitor c=cap
    C8 (ADC_INN net04) capacitor c=128*cap
    C7 (ADC_INN net05) capacitor c=64*cap
    C4 (ADC_INN net08) capacitor c=8*cap
    C6 (ADC_INN net06) capacitor c=32*cap
    C5 (ADC_INN net07) capacitor c=16*cap
    C1 (ADC_INN net26) capacitor c=cap
    C3 (ADC_INN net09) capacitor c=4*cap
    C2 (ADC_INN net010) capacitor c=2*cap
    I1 (ADC_INN VREF COMP_OUT VDD VSS net017) COMP
    I7 (B\<7\> B\<6\> B\<5\> B\<4\> B\<3\> B\<2\> B\<1\> B\<0\> D\<7\> D\<6\> D\<5\> D\<4\> D\<3\> D\<2\> D\<1\> D\<0\> VDD VREF VSS) ADC_ctrl
    I8 (CLK net017 VDD VSS) inverter
    I24 (VDD VSS B\<0\> net26 CMP) sw_cmos
    I23 (VDD VSS VIN net010 LD) sw_cmos
    I25 (VDD VSS VIN net26 LD) sw_cmos
    I26 (VDD VSS VIN net071 LD) sw_cmos
    I20 (VDD VSS B\<2\> net09 CMP) sw_cmos
    I19 (VDD VSS VIN net08 LD) sw_cmos
    I21 (VDD VSS VIN net09 LD) sw_cmos
    I22 (VDD VSS B\<1\> net010 CMP) sw_cmos
    I18 (VDD VSS B\<3\> net08 CMP) sw_cmos
    I17 (VDD VSS B\<4\> net07 CMP) sw_cmos
    I14 (VDD VSS B\<5\> net06 CMP) sw_cmos
    I13 (VDD VSS VIN net05 LD) sw_cmos
    I15 (VDD VSS VIN net06 LD) sw_cmos
    I16 (VDD VSS VIN net07 LD) sw_cmos
    I12 (VDD VSS B\<6\> net05 CMP) sw_cmos
    I11 (VDD VSS VIN net04 LD) sw_cmos
    I10 (VDD VSS B\<7\> net04 CMP) sw_cmos
    I27 (VDD VSS VSS net071 CMP) sw_cmos
ends ADC

// ee140_gsi/invr_dupe/schematic
subckt invr_dupe in out VDD VSS
parameters GT_PDW GT_PDL=180.00n sx=4.8e-07 lc=2.7e-07 GT_PUW GT_PUL=180.00n
    ne (out in VSS VSS) ne w=GT_PDW l=GT_PDL m=(1)*(1)
    pe (out in VDD VDD) pe w=GT_PUW l=GT_PUL m=(1)*(1)
ends invr_dupe

// ee140_gsi/DFRRSHDX0_dupe/schematic
subckt DFRRSHDX0_dupe C D Q QN RN SN VDD VSS
    I0 (C CIB VDD VSS) invr_dupe GT_PDW=420.0n GT_PDL=180.00n sx=4.8e-07 lc=2.7e-07 GT_PUW=720.00n GT_PUL=180.00n
    I2 (SQI QN VDD VSS) invr_dupe GT_PDW=420.0n GT_PDL=180.00n sx=4.8e-07 lc=2.7e-07 GT_PUW=720.00n GT_PUL=180.00n
    I1 (CIB CI VDD VSS) invr_dupe GT_PDW=420.0n GT_PDL=180.00n sx=4.8e-07 lc=2.7e-07 GT_PUW=720.00n GT_PUL=180.00n
    I3 (SQIB Q VDD VSS) invr_dupe GT_PDW=420.0n GT_PDL=180.00n sx=4.8e-07 lc=2.7e-07 GT_PUW=720.00n GT_PUL=180.00n
    MN10 (SQIB CI net268 VSS) ne w=420.0n l=180.0n m=(1)*(1)
    MN14 (SQIB CIB net266 VSS) ne w=420.0n l=180.0n m=(1)*(1)
    MN2 (MQIB CIB net271 VSS) ne w=420.0n l=180.0n m=(1)*(1)
    MN6 (MQIB CI net270 VSS) ne w=420.0n l=180.0n m=(1)*(1)
    MN13 (net266 SQI net265 VSS) ne w=420.0n l=180.0n m=(1)*(1)
    MN7 (MQI MQIB net269 VSS) ne w=505.00n l=180.0n m=(1)*(1)
    MN15 (SQI SQIB net264 VSS) ne w=890.0n l=180.0n m=(1)*(1)
    MN9 (net268 MQI net267 VSS) ne w=420.0n l=180.0n m=(1)*(1)
    MN1 (net271 D net273 VSS) ne w=420.0n l=180.0n m=(1)*(1)
    MN5 (net270 MQI net272 VSS) ne w=420.0n l=180.0n m=(1)*(1)
    MN11 (net267 RN VSS VSS) ne w=420.0n l=180.0n m=(1)*(1)
    MN16 (net264 SN VSS VSS) ne w=890.0n l=180.0n m=(1)*(1)
    MN12 (net265 RN VSS VSS) ne w=420.0n l=180.0n m=(1)*(1)
    MN8 (net269 SN VSS VSS) ne w=505.00n l=180.0n m=(1)*(1)
    MN3 (net273 RN VSS VSS) ne w=420.0n l=180.0n m=(1)*(1)
    MN4 (net272 RN VSS VSS) ne w=420.0n l=180.0n m=(1)*(1)
    MP3 (MQIB RN VDD VDD) pe w=955.00n l=180.0n m=(1)*(1)
    MP14 (SQI SN VDD VDD) pe w=925.00n l=180.0n m=(1)*(1)
    MP10 (SQIB RN VDD VDD) pe w=505.00n l=180.0n m=(1)*(1)
    MP6 (MQI MQIB VDD VDD) pe w=850.0n l=180.0n m=(1)*(1)
    MP9 (net261 MQI VDD VDD) pe w=715.00n l=180.0n m=(1)*(1)
    MP7 (MQI SN VDD VDD) pe w=850.0n l=180.0n m=(1)*(1)
    MP13 (SQI SQIB VDD VDD) pe w=925.00n l=180.0n m=(1)*(1)
    MP12 (net260 SQI VDD VDD) pe w=420.0n l=180.0n m=(1)*(1)
    MP5 (net262 MQI VDD VDD) pe w=420.0n l=180.0n m=(1)*(1)
    MP2 (net263 D VDD VDD) pe w=705.00n l=180.0n m=(1)*(1)
    MP11 (SQIB CI net260 VDD) pe w=420.0n l=180.0n m=(1)*(1)
    MP4 (MQIB CIB net262 VDD) pe w=420.0n l=180.0n m=(1)*(1)
    MP8 (SQIB CIB net261 VDD) pe w=715.00n l=180.0n m=(1)*(1)
    MP1 (MQIB CI net263 VDD) pe w=705.00n l=180.0n m=(1)*(1)
ends DFRRSHDX0_dupe

// final_project/SAR_DFF/schematic
subckt SAR_DFF CLK COMP D\<7\> D\<6\> D\<5\> D\<4\> D\<3\> D\<2\> D\<1\> D\<0\> RESETB DONE VDD VSS
    I18 (VSS VSS DONE net019 RESETB net010 VDD VSS) DFRRSHDX0_dupe
    I17 (DONE COMP D\<0\> net067 RESETB net014 VDD VSS) DFRRSHDX0_dupe
    I16 (D\<0\> COMP D\<1\> net025 RESETB net018 VDD VSS) DFRRSHDX0_dupe
    I15 (D\<1\> COMP D\<2\> net029 RESETB net022 VDD VSS) DFRRSHDX0_dupe
    I14 (D\<2\> COMP D\<3\> net033 RESETB net026 VDD VSS) DFRRSHDX0_dupe
    I13 (D\<3\> COMP D\<4\> net065 RESETB net030 VDD VSS) DFRRSHDX0_dupe
    I12 (D\<4\> COMP D\<5\> net043 RESETB net034 VDD VSS) DFRRSHDX0_dupe
    I11 (D\<5\> COMP D\<6\> net048 RESETB net038 VDD VSS) DFRRSHDX0_dupe
    I10 (D\<6\> COMP D\<7\> net053 RESETB net2 VDD VSS) DFRRSHDX0_dupe
    I8 (CLK X\<0\> net09 net010 RESETB VDD VDD VSS) DFRRSHDX0_dupe
    I7 (CLK X\<1\> X\<0\> net014 RESETB VDD VDD VSS) DFRRSHDX0_dupe
    I6 (CLK X\<2\> X\<1\> net018 RESETB VDD VDD VSS) DFRRSHDX0_dupe
    I5 (CLK X\<3\> X\<2\> net022 RESETB VDD VDD VSS) DFRRSHDX0_dupe
    I4 (CLK X\<4\> X\<3\> net026 RESETB VDD VDD VSS) DFRRSHDX0_dupe
    I3 (CLK X\<5\> X\<4\> net030 RESETB VDD VDD VSS) DFRRSHDX0_dupe
    I2 (CLK X\<6\> X\<5\> net034 RESETB VDD VDD VSS) DFRRSHDX0_dupe
    I1 (CLK X\<7\> X\<6\> net038 RESETB VDD VDD VSS) DFRRSHDX0_dupe
    I0 (CLK VSS X\<7\> net2 VDD RESETB VDD VSS) DFRRSHDX0_dupe
ends SAR_DFF

// final_project/zz_ADC/schematic
I0 (CLK VIB D\<7\> D\<6\> D\<5\> D\<4\> D\<3\> D\<2\> D\<1\> D\<0\> VDD VIN VREF VSS CMP LD) ADC
V3 (VIN VSS) vsource dc=vin type=dc
V2 (VREF VSS) vsource dc=ref type=dc
V1 (VDD VSS) vsource dc=supply type=dc
V0 (VSS 0) vsource dc=0 type=dc
V14 (D\<2\> VSS) vsource type=pulse val0=0 val1=d2 delay=3u rise=10n fall=10n
V13 (D\<1\> VSS) vsource type=pulse val0=0 val1=d1 delay=3u rise=10n fall=10n
V12 (D\<0\> VSS) vsource type=pulse val0=0 val1=d0 delay=3u rise=10n fall=10n
V11 (D\<3\> VSS) vsource type=pulse val0=0 val1=d3 delay=3u rise=10n fall=10n
V10 (D\<4\> VSS) vsource type=pulse val0=0 val1=d4 delay=3u rise=10n fall=10n
V9 (D\<5\> VSS) vsource type=pulse val0=0 val1=d5 delay=3u rise=10n fall=10n
V8 (D\<6\> VSS) vsource type=pulse val0=0 val1=d6 delay=3u rise=10n fall=10n
V7 (D\<7\> VSS) vsource type=pulse val0=0 val1=d7 delay=3u rise=10n fall=10n
V6 (CMP VSS) vsource type=pulse val0=0 val1=supply delay=2u rise=10n fall=10n
V5 (LD VSS) vsource type=pulse val0=0 val1=supply rise=10n fall=10n width=2u
V4 (CLK VSS) vsource type=pulse val0=0 val1=supply period=1u rise=10n fall=10n width=500.0n
I2 (CLK VIB net03\<0\> net03\<1\> net03\<2\> net03\<3\> net03\<4\> net03\<5\> net03\<6\> net03\<7\> VDD net1 VDD VSS) SAR_DFF
simulatorOptions options reltol=100e-6 temp=27 homotopy=all limit=delta compatible=spice2
tran tran stop=4u errpreset=liberal
