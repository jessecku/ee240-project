// Design: final_project/zz_ADC
simulator lang=spectre
global 0
parameters d0=0 d1=0 d2=0 d3=0 d4=0 d5=0 d6=0 d7=1 cap=100p ref=1 supply=1.2 vin=0.4
include "/home/ff/ee140/fa19/xfab/XKIT/xt018/cadence/v8_0/spectre/v8_0_2/lp5mos/config.scs" section=default
include "/home/ff/ee140/fa19/xfab/XKIT/xt018/cadence/v8_0/spectre/v8_0_2/lp5mos/param.scs" section=3s
include "/home/ff/ee140/fa19/xfab/XKIT/xt018/cadence/v8_0/spectre/v8_0_2/lp5mos/bip.scs" section=tm
include "/home/ff/ee140/fa19/xfab/XKIT/xt018/cadence/v8_0/spectre/v8_0_2/lp5mos/cap.scs" section=tm
include "/home/ff/ee140/fa19/xfab/XKIT/xt018/cadence/v8_0/spectre/v8_0_2/lp5mos/dio.scs" section=tm
include "/home/ff/ee140/fa19/xfab/XKIT/xt018/cadence/v8_0/spectre/v8_0_2/lp5mos/mos.scs" section=tm
include "/home/ff/ee140/fa19/xfab/XKIT/xt018/cadence/v8_0/spectre/v8_0_2/lp5mos/res.scs" section=tm

// final_project/inverter/schematic
subckt inverter IN OUT VDD VSS
    M0 (OUT IN VSS VSS) ne w=220.0n l=180.0n m=(1)*(1)
    M1 (OUT IN VDD VDD) pe w=220.0n l=180.0n m=(1)*(1)
ends inverter

// final_project/COMP/schematic
subckt COMP INN INP OUT VDD VSS CLK
    S2 (Q CLK VDD VDD) pe w=220.0n l=180.0n m=(1)*(1)
    S4 (Y CLK VDD VDD) pe w=220.0n l=180.0n m=(1)*(1)
    M3L (X Y VDD VDD) pe w=220.0n l=180.0n m=(1)*(1)
    S1 (P CLK VDD VDD) pe w=220.0n l=180.0n m=(1)*(1)
    S3 (X CLK VDD VDD) pe w=220.0n l=180.0n m=(1)*(1)
    M3R (Y X VDD VDD) pe w=220.0n l=180.0n m=(1)*(1)
    S5 (net15 CLK VSS VSS) ne w=220.0n l=180.0n m=(1)*(1)
    M1R (Q INN net15 net15) ne w=220.0n l=180.0n m=(1)*(1)
    M1L (P INP net15 net15) ne w=220.0n l=180.0n m=(1)*(1)
    M2R (Y X Q Q) ne w=220.0n l=180.0n m=(1)*(1)
    M2L (X Y P P) ne w=220.0n l=180.0n m=(1)*(1)
    I2 (X OUT VDD VSS) inverter
    I1 (Y net025 VDD VSS) inverter
ends COMP

// final_project/mux2/schematic
subckt mux2 S\<0\> VDD VSS in0 in1 out
    W1 (in0 out net8 VSS) relay vt1=100m vt2=900m ropen=1T rclosed=1.0
    W0 (in1 out S\<0\> VSS) relay vt1=100m vt2=900.0m ropen=1T rclosed=1.0
    I0 (S\<0\> net8 VDD VSS) inverter
ends mux2

// final_project/ADC_ctrl/schematic
subckt ADC_ctrl B\<7\> B\<6\> B\<5\> B\<4\> B\<3\> B\<2\> B\<1\> B\<0\> S\<7\> S\<6\> S\<5\> S\<4\> S\<3\> S\<2\> S\<1\> S\<0\> VDD VREF VSS
    I5 (S\<5\> VDD VSS VSS VREF B\<5\>) mux2
    I7 (S\<7\> VDD VSS VSS VREF B\<7\>) mux2
    I4 (S\<4\> VDD VSS VSS VREF B\<4\>) mux2
    I1 (S\<1\> VDD VSS VSS VREF B\<1\>) mux2
    I3 (S\<3\> VDD VSS VSS VREF B\<3\>) mux2
    I6 (S\<6\> VDD VSS VSS VREF B\<6\>) mux2
    I2 (S\<2\> VDD VSS VSS VREF B\<2\>) mux2
    I0 (S\<0\> VDD VSS VSS VREF B\<0\>) mux2
ends ADC_ctrl

// final_project/ADC/schematic
subckt ADC CLK COMP_OUT D\<7\> D\<6\> D\<5\> D\<4\> D\<3\> D\<2\> D\<1\> D\<0\> VDD VIN VREF VSS CMP LD
    W21 (net05 B\<6\> CMP VSS) relay ropen=1T rclosed=1.0
    W20 (net05 VIN LD VSS) relay ropen=1T rclosed=1.0
    W19 (net04 VIN LD VSS) relay ropen=1T rclosed=1.0
    W18 (net04 B\<7\> CMP VSS) relay ropen=1T rclosed=1.0
    W17 (net07 B\<4\> CMP VSS) relay ropen=1T rclosed=1.0
    W16 (net07 VIN LD VSS) relay ropen=1T rclosed=1.0
    W15 (net06 VIN LD VSS) relay ropen=1T rclosed=1.0
    W14 (net06 B\<5\> CMP VSS) relay ropen=1T rclosed=1.0
    W13 (net08 B\<3\> CMP VSS) relay ropen=1T rclosed=1.0
    W12 (net08 VIN LD VSS) relay ropen=1T rclosed=1.0
    W9 (net010 B\<1\> CMP VSS) relay ropen=1T rclosed=1.0
    W8 (net010 VIN LD VSS) relay ropen=1T rclosed=1.0
    W22 (net071 VIN LD VSS) relay ropen=1T rclosed=1.0
    W11 (net09 VIN LD VSS) relay ropen=1T rclosed=1.0
    W10 (net09 B\<2\> CMP VSS) relay ropen=1T rclosed=1.0
    W3 (net26 B\<0\> CMP VSS) relay ropen=1T rclosed=1.0
    W2 (net26 VIN LD VSS) relay ropen=1T rclosed=1.0
    W23 (net071 B\<0\> CMP VSS) relay ropen=1T rclosed=1.0
    W0 (VREF net8 LD VSS) relay ropen=1T rclosed=1.0
    C0 (net8 net071) capacitor c=cap
    C8 (net8 net04) capacitor c=128*cap
    C7 (net8 net05) capacitor c=64*cap
    C4 (net8 net08) capacitor c=8*cap
    C6 (net8 net06) capacitor c=32*cap
    C5 (net8 net07) capacitor c=16*cap
    C1 (net8 net26) capacitor c=cap
    C3 (net8 net09) capacitor c=4*cap
    C2 (net8 net010) capacitor c=2*cap
    I1 (net8 VREF COMP_OUT VDD VSS net017) COMP
    I7 (B\<7\> B\<6\> B\<5\> B\<4\> B\<3\> B\<2\> B\<1\> B\<0\> D\<7\> D\<6\> D\<5\> D\<4\> D\<3\> D\<2\> D\<1\> D\<0\> VDD VREF VSS) ADC_ctrl
    I8 (CLK net017 VDD VSS) inverter
ends ADC

// final_project/zz_ADC/schematic
I0 (CLK VIB D\<7\> D\<6\> D\<5\> D\<4\> D\<3\> D\<2\> D\<1\> D\<0\> VDD VIN VREF VSS CMP LD) ADC
V14 (D\<0\> VSS) vsource dc=d0 type=dc
V13 (D\<1\> VSS) vsource dc=d1 type=dc
V12 (D\<2\> VSS) vsource dc=d2 type=dc
V11 (D\<3\> VSS) vsource dc=d3 type=dc
V10 (D\<4\> VSS) vsource dc=d4 type=dc
V9 (D\<5\> VSS) vsource dc=d5 type=dc
V3 (VIN VSS) vsource dc=vin type=dc
V2 (VREF VSS) vsource dc=ref type=dc
V1 (VDD VSS) vsource dc=supply type=dc
V0 (VSS 0) vsource dc=0 type=dc
V8 (D\<6\> VSS) vsource dc=d6 type=pulse val0=0 val1=1 delay=40u rise=5n fall=5n
V7 (D\<7\> VSS) vsource dc=0 type=pulse val0=0 val1=1 delay=20u rise=5n fall=5n width=10u
V6 (CMP VSS) vsource type=pulse val0=0 val1=1 delay=10u rise=5n fall=5n
V5 (LD VSS) vsource type=pulse val0=0 val1=1 rise=5n fall=5n width=10u
V4 (CLK VSS) vsource type=pulse val0=0 val1=1 period=10u rise=5n fall=5n width=5u
simulatorOptions options reltol=100e-6 temp=27 homotopy=all limit=delta compatible=spice2
tran tran stop=50u errpreset=conservative
