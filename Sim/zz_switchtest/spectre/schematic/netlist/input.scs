// Design: final_project/zz_switchtest
simulator lang=spectre
global 0
parameters ctrl_c=0 ctrl_n=0 ctrl_p=1.2 supply=1.2 test=1
include "/home/ff/ee140/fa19/xfab/XKIT/xt018/cadence/v8_0/spectre/v8_0_2/lp5mos/config.scs" section=default
include "/home/ff/ee140/fa19/xfab/XKIT/xt018/cadence/v8_0/spectre/v8_0_2/lp5mos/param.scs" section=3s
include "/home/ff/ee140/fa19/xfab/XKIT/xt018/cadence/v8_0/spectre/v8_0_2/lp5mos/bip.scs" section=tm
include "/home/ff/ee140/fa19/xfab/XKIT/xt018/cadence/v8_0/spectre/v8_0_2/lp5mos/cap.scs" section=tm
include "/home/ff/ee140/fa19/xfab/XKIT/xt018/cadence/v8_0/spectre/v8_0_2/lp5mos/dio.scs" section=tm
include "/home/ff/ee140/fa19/xfab/XKIT/xt018/cadence/v8_0/spectre/v8_0_2/lp5mos/mos.scs" section=tm
include "/home/ff/ee140/fa19/xfab/XKIT/xt018/cadence/v8_0/spectre/v8_0_2/lp5mos/res.scs" section=tm

// final_project/inverter/schematic
subckt inverter IN OUT VDD VSS
    M0 (OUT IN VSS VSS) ne w=220.0n l=180.0n m=(1)*(1)
    M1 (OUT IN VDD VDD) pe w=220.0n l=180.0n m=(1)*(1)
ends inverter

// final_project/sw_cmos/schematic
subckt sw_cmos VDD VSS io0 io1 sw_ctrl
    M0 (io0 sw_ctrl io1 VSS) ne w=220.0n l=180.0n m=(1)*(1)
    M1 (io0 sw_ctrl_bar io1 VDD) pe w=220.0n l=180.0n m=(1)*(1)
    I0 (sw_ctrl sw_ctrl_bar VDD VSS) inverter
ends sw_cmos

// final_project/sw_pmos/schematic
subckt sw_pmos VSS io0 io1 sw_ctrl VDD
    I0 (sw_ctrl net13 VDD VSS) inverter
    M0 (io1 net13 io0 VDD) pe w=220.0n l=180.0n m=(1)*(1)
ends sw_pmos

// final_project/sw_nmos/schematic
subckt sw_nmos VSS io0 io1 sw_ctrl
    M0 (io0 sw_ctrl io1 VSS) ne w=220.0n l=180.0n m=(1)*(1)
ends sw_nmos

// final_project/zz_switchtest/schematic
I0 (VDD 0 net2 net7 sw_ctrl_c) sw_cmos
I1 (0 net2 net6 sw_ctrl_p VDD) sw_pmos
I2 (0 net04 0 sw_ctrl_n) sw_nmos
R3 (net2 net04) resistor r=1
R1 (net6 0) resistor r=1
R0 (net7 0) resistor r=1
V4 (sw_ctrl_c 0) vsource dc=ctrl_c type=dc
V3 (sw_ctrl_p 0) vsource dc=ctrl_p type=dc
V2 (sw_ctrl_n 0) vsource dc=ctrl_n type=dc
V1 (VDD 0) vsource dc=supply type=dc
V0 (net2 0) vsource dc=test type=dc
simulatorOptions options reltol=100e-6 temp=27 homotopy=all limit=delta compatible=spice2
dcOp dc
save R0:1 R1:1 R3:1
