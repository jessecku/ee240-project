// Design: final_project/zz_comp
simulator lang=spectre
global 0
parameters supply=1.2 Vneg=1.1 Vplus=0.7
include "/home/ff/ee140/fa19/xfab/XKIT/xt018/cadence/v8_0/spectre/v8_0_2/lp5mos/config.scs" section=default
include "/home/ff/ee140/fa19/xfab/XKIT/xt018/cadence/v8_0/spectre/v8_0_2/lp5mos/param.scs" section=3s
include "/home/ff/ee140/fa19/xfab/XKIT/xt018/cadence/v8_0/spectre/v8_0_2/lp5mos/bip.scs" section=tm
include "/home/ff/ee140/fa19/xfab/XKIT/xt018/cadence/v8_0/spectre/v8_0_2/lp5mos/cap.scs" section=tm
include "/home/ff/ee140/fa19/xfab/XKIT/xt018/cadence/v8_0/spectre/v8_0_2/lp5mos/dio.scs" section=tm
include "/home/ff/ee140/fa19/xfab/XKIT/xt018/cadence/v8_0/spectre/v8_0_2/lp5mos/mos.scs" section=tm
include "/home/ff/ee140/fa19/xfab/XKIT/xt018/cadence/v8_0/spectre/v8_0_2/lp5mos/res.scs" section=tm

// final_project/inverter/schematic
subckt inverter IN OUT VDD VSS
    M0 (OUT IN VSS VSS) ne w=220.0n l=180.0n m=(1)*(1)
    M1 (OUT IN VDD VDD) pe w=220.0n l=180.0n m=(1)*(1)
ends inverter

// final_project/SR_latch/schematic
subckt SR_latch VDD VSS X Y out
    I3 (Y net11 VDD VSS) inverter
    I2 (X net12 VDD VSS) inverter
    I1 (out net7 VDD VSS) inverter
    I0 (net7 out VDD VSS) inverter
    M1 (out net11 VSS VSS) ne w=220.0n l=180.0n m=(1)*(1)
    M0 (net7 net12 VSS VSS) ne w=220.0n l=180.0n m=(1)*(1)
ends SR_latch

// final_project/COMP/schematic
subckt COMP INN INP OUT VDD VSS CLK
    S2 (Q CLK VDD VDD) pe w=220.0n l=180.0n m=(1)*(1)
    S4 (Y CLK VDD VDD) pe w=220.0n l=180.0n m=(1)*(1)
    M3L (X Y VDD VDD) pe w=220.0n l=180.0n m=(1)*(1)
    S1 (P CLK VDD VDD) pe w=220.0n l=180.0n m=(1)*(1)
    S3 (X CLK VDD VDD) pe w=220.0n l=180.0n m=(1)*(1)
    M3R (Y X VDD VDD) pe w=220.0n l=180.0n m=(1)*(1)
    S5 (net15 CLK VSS VSS) ne w=220.0n l=180.0n m=(1)*(1)
    M1R (Q INN net15 net15) ne w=220.0n l=180.0n m=(1)*(1)
    M1L (P INP net15 net15) ne w=220.0n l=180.0n m=(1)*(1)
    M2R (Y X Q Q) ne w=220.0n l=180.0n m=(1)*(1)
    M2L (X Y P P) ne w=220.0n l=180.0n m=(1)*(1)
    I9 (VDD VSS X Y OUT) SR_latch
ends COMP

// final_project/zz_comp/schematic
I0 (VIN VIP OUT VDD VSS CLK) COMP
V3 (VIN VSS) vsource dc=Vneg type=dc
V2 (VIP VSS) vsource dc=Vplus type=dc
V1 (VDD VSS) vsource dc=supply type=dc
V0 (VSS 0) vsource dc=0 type=dc
V4 (CLK VSS) vsource dc=0 type=pulse val0=0 val1=1 period=20u delay=10n rise=10n fall=10n width=10u
simulatorOptions options reltol=100e-6 temp=27 homotopy=all limit=delta compatible=spice2
tran tran stop=10u errpreset=conservative
