// Design: final_project/zz_ADC_ctrl
simulator lang=spectre
global 0
parameters ref=1.1 s0=1 s1=0 s2=1 s3=0 s4=1 s5=0 s6=1 s7=0 supply=1.2
include "/home/ff/ee140/fa19/xfab/XKIT/xt018/cadence/v8_0/spectre/v8_0_2/lp5mos/config.scs" section=default
include "/home/ff/ee140/fa19/xfab/XKIT/xt018/cadence/v8_0/spectre/v8_0_2/lp5mos/param.scs" section=3s
include "/home/ff/ee140/fa19/xfab/XKIT/xt018/cadence/v8_0/spectre/v8_0_2/lp5mos/bip.scs" section=tm
include "/home/ff/ee140/fa19/xfab/XKIT/xt018/cadence/v8_0/spectre/v8_0_2/lp5mos/cap.scs" section=tm
include "/home/ff/ee140/fa19/xfab/XKIT/xt018/cadence/v8_0/spectre/v8_0_2/lp5mos/dio.scs" section=tm
include "/home/ff/ee140/fa19/xfab/XKIT/xt018/cadence/v8_0/spectre/v8_0_2/lp5mos/mos.scs" section=tm
include "/home/ff/ee140/fa19/xfab/XKIT/xt018/cadence/v8_0/spectre/v8_0_2/lp5mos/res.scs" section=tm

// final_project/inverter/schematic
subckt inverter IN OUT VDD VSS
    M0 (OUT IN VSS VSS) ne w=220.0n l=180.0n m=(1)*(1)
    M1 (OUT IN VDD VDD) pe w=220.0n l=180.0n m=(1)*(1)
ends inverter

// final_project/mux2/schematic
subckt mux2 S\<0\> VDD VSS in0 in1 out
    W1 (in0 out net8 VSS) relay vt1=100m vt2=900m ropen=1T rclosed=1.0
    W0 (in1 out S\<0\> VSS) relay vt1=100m vt2=900.0m ropen=1T rclosed=1.0
    I0 (S\<0\> net8 VDD VSS) inverter
ends mux2

// final_project/ADC_ctrl/schematic
subckt ADC_ctrl B\<7\> B\<6\> B\<5\> B\<4\> B\<3\> B\<2\> B\<1\> B\<0\> S\<7\> S\<6\> S\<5\> S\<4\> S\<3\> S\<2\> S\<1\> S\<0\> VDD VREF VSS
    I5 (S\<5\> VDD VSS VSS VREF B\<5\>) mux2
    I7 (S\<7\> VDD VSS VSS VREF B\<7\>) mux2
    I4 (S\<4\> VDD VSS VSS VREF B\<4\>) mux2
    I1 (S\<1\> VDD VSS VSS VREF B\<1\>) mux2
    I3 (S\<3\> VDD VSS VSS VREF B\<3\>) mux2
    I6 (S\<6\> VDD VSS VSS VREF B\<6\>) mux2
    I2 (S\<2\> VDD VSS VSS VREF B\<2\>) mux2
    I0 (S\<0\> VDD VSS VSS VREF B\<0\>) mux2
ends ADC_ctrl

// final_project/zz_ADC_ctrl/schematic
I0 (B\<7\> B\<6\> B\<5\> B\<4\> B\<3\> B\<2\> B\<1\> B\<0\> S\<7\> S\<6\> S\<5\> S\<4\> S\<3\> S\<2\> S\<1\> S\<0\> VDD VREF VSS) ADC_ctrl
V10 (S\<0\> VSS) vsource dc=s0 type=dc
V9 (S\<1\> VSS) vsource dc=s1 type=dc
V8 (S\<2\> VSS) vsource dc=s2 type=dc
V7 (S\<3\> VSS) vsource dc=s3 type=dc
V6 (S\<4\> VSS) vsource dc=s4 type=dc
V5 (S\<5\> VSS) vsource dc=s5 type=dc
V4 (S\<6\> VSS) vsource dc=s6 type=dc
V3 (S\<7\> VSS) vsource dc=s7 type=dc
V2 (VREF VSS) vsource dc=ref type=dc
V1 (VDD VSS) vsource dc=supply type=dc
V0 (VSS 0) vsource dc=0 type=dc
simulatorOptions options reltol=100e-6 temp=27 homotopy=all limit=delta compatible=spice2
dcOp dc
