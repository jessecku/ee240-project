ADE simulation setup
Run mode: Single Run, Sweeps and Corners
Tests:
  ee140_gsi:zz_EE140_Fa19_digital:1: ee140_gsi/zz_EE140_Fa19_digital/config, simulator ams
Global variables:
  VDD = 1.2
  VCOMP = 0
  TRISE = 10n
  TFALL = 10n
  FCLK = 1M
  VCLK = VDD
  TSTART = 1/FCLK
